* ldo_erramp_placeholder -- generated by design/netlist.py from design/ldo_erramp_placeholder.sch
* Do not edit: edit the schematic and re-run the export.
** sch_path: design/ldo_erramp_placeholder.sch
.subckt ldo_erramp_placeholder INP INN OUT VDD VSS
*.PININFO INP:I INN:I OUT:O VDD:B VSS:B
Bamp ERR_INT VSS V = 'min(V(vdd),max(V(vss),3162*(V(inp)-V(inn))))' m=1
Rout ERR_INT OUT 1Meg m=1
Rplaceholder_vdd VDD VSS 1T m=1
.ends
