* fb_divider -- generated by layout/drclvs.py from layout/divider/fb_divider.sch
* LVS reference netlist (xschem lvs_netlist form). Do not edit: edit
* the schematic and re-run the export.
** sch_path: layout/divider/fb_divider.sch
.subckt fb_divider VOUT_S FB VSS
*.PININFO VOUT_S:B FB:B VSS:B
Rb1 nb1 VSS VSS ppolyf_u_3k W=2u L=31.8u m=1
Rb2 nb2 nb1 VSS ppolyf_u_3k W=2u L=31.8u m=1
Rb3 nb3 nb2 VSS ppolyf_u_3k W=2u L=31.8u m=1
Rb4 nb4 nb3 VSS ppolyf_u_3k W=2u L=31.8u m=1
Rb5 nb5 nb4 VSS ppolyf_u_3k W=2u L=31.8u m=1
Rb6 nb6 nb5 VSS ppolyf_u_3k W=2u L=31.8u m=1
Rb7 nb7 nb6 VSS ppolyf_u_3k W=2u L=31.8u m=1
Rb8 nb8 nb7 VSS ppolyf_u_3k W=2u L=31.8u m=1
Rb9 nb9 nb8 VSS ppolyf_u_3k W=2u L=31.8u m=1
Rb10 nb10 nb9 VSS ppolyf_u_3k W=2u L=31.8u m=1
Rb11 nb11 nb10 VSS ppolyf_u_3k W=2u L=31.8u m=1
Rb12 FB nb11 VSS ppolyf_u_3k W=2u L=31.8u m=1
Rt1 nt1 FB VSS ppolyf_u_3k W=2u L=31.8u m=1
Rt2 nt2 nt1 VSS ppolyf_u_3k W=2u L=31.8u m=1
Rt3 nt3 nt2 VSS ppolyf_u_3k W=2u L=31.8u m=1
Rt4 nt4 nt3 VSS ppolyf_u_3k W=2u L=31.8u m=1
Rt5 nt5 nt4 VSS ppolyf_u_3k W=2u L=31.8u m=1
Rt6 VOUT_S nt5 VSS ppolyf_u_3k W=2u L=31.8u m=1
Rdum0 VSS VSS VSS ppolyf_u_3k W=2u L=31.8u m=1
Rdum19 VSS VSS VSS ppolyf_u_3k W=2u L=31.8u m=1
.ends
