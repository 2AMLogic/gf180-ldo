* drclvs_passives -- generated by layout/drclvs.py from layout/passives/drclvs_passives.sch
* LVS reference netlist (xschem lvs_netlist form). Do not edit: edit
* the schematic and re-run the export.
* 2 passive device line(s) rendered as primitive R/C
* elements by layout/lvs_form.py -- the PDK's resistor and MIM-cap
* symbols carry no lvs_format attribute (issue #313).
** sch_path: layout/passives/drclvs_passives.sch
.subckt drclvs_passives RP RM CT CB D G S VSS
*.PININFO RP:B RM:B CT:B CB:B D:B G:I S:B VSS:B
R1 RM RP VSS ppolyf_u_1k l=10u w=1u m=1
C1 CT CB cap_mim_2f0_m4m5_noshield l=20u w=20u m=1
M1 D G S VSS nfet_03v3 L=0.28u W=6u nf=2 m=1
.ends
