* drclvs_testcell -- generated by layout/drclvs.py from layout/testcell/drclvs_testcell.sch
* LVS reference netlist (xschem lvs_netlist form). Do not edit: edit
* the schematic and re-run the export.
** sch_path: layout/testcell/drclvs_testcell.sch
.subckt drclvs_testcell D G S VSS
*.PININFO D:B G:I S:B VSS:B
M1 D G S VSS nfet_03v3 L=0.28u W=2u nf=1 m=1
.ends
