* Reference netlist for layout/poly_flavour (issue #312, DR-0037).
* Single-flavour 3k die: both H-Res strips ppolyf_u_3k, plus plain ppolyf_u.
* This is the form DR-0037 requires of the design (poly_res=3k).
.subckt TOP A B E F C D VSS
R1 A B VSS ppolyf_u_3k l=10u w=1u m=1
R2 E F VSS ppolyf_u_3k l=10u w=1u m=1
R3 C D VSS ppolyf_u l=10u w=1u m=1
.ends
