* Reference netlist for layout/poly_flavour (issue #312, DR-0037).
* The mixed form DR-0037 forbids (error_amp as DR-0033 committed it): the
* two identical H-Res strips named as one ppolyf_u_1k and one ppolyf_u_3k.
.subckt TOP A B E F C D VSS
R1 A B VSS ppolyf_u_1k l=10u w=1u m=1
R2 E F VSS ppolyf_u_3k l=10u w=1u m=1
R3 C D VSS ppolyf_u l=10u w=1u m=1
.ends
