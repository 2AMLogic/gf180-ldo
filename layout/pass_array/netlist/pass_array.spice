* pass_array -- generated by layout/drclvs.py from layout/pass_array/pass_array.sch
* LVS reference netlist (xschem lvs_netlist form). Do not edit: edit
* the schematic and re-run the export.
** sch_path: layout/pass_array/pass_array.sch
.subckt pass_array VIN VOUT ISNS PASS_GATE
*.PININFO VIN:B VOUT:B ISNS:B PASS_GATE:I
Mpass VOUT PASS_GATE VIN VIN pfet_03v3 L=0.28u W=2800u nf=40 m=1
Msense ISNS PASS_GATE VIN VIN pfet_03v3 L=0.28u W=70u nf=1 m=1
.ends
