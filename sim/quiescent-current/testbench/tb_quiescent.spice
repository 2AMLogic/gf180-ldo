* quiescent-current -- stimulus fragment for ldo_core (issue #12)
*
* Iq (README.md Target specification, "Iq" row; DR-0004 amendment A6):
* <30uA at no load, binds ff/125C/3.63V. Also measures the "Enable /
* shutdown" row's shutdown-Iq clause (A9): <3uA at the same corner.
*
* Three independent ldo_core instances share one Vsup but have separate
* zero-volt "ammeter" probes and separate EN wiring, so all three states
* are captured in a SINGLE op analysis -- no ngspice "alter" needed (see
* psrr-vs-freq's header comment for why alter-between-analyses was
* rejected as unreliable for this harness's let/print ordering):
*   - _en   : EN tied to VIN (enabled, no load)   -> the primary Iq claim
*   - _dis  : EN tied to 0  (disabled/shutdown)   -> shutdown Iq clause
*   - _full : EN tied to VIN, 50 mA load          -> Iq "at full load"
*             (the ratified row requires <30uA at BOTH no load and full
*             load; Iq excludes load current, so iq_full_ua below
*             subtracts the deliberately-injected 50 mA back out)
* All three instances see 0 mA external load except _full's Iload.
Vsup VIN 0 DC {vdd_val}

Vamm_en VIN VIN_EN 0
* --- Reference (issue #174 / DR-0021) ------------------------------------
* VREF is a TOP-LEVEL PORT of ldo_core as of #174; it used to be an internal
* net driven by Vref1, an ideal 1.2 V vsource instantiated INSIDE the
* subcircuit. That source is deleted from design/ldo_core.sch and reappears
* here, unchanged, at deck level. This is an electrical no-op by
* construction: an ideal vsource is an ideal vsource wherever it is
* declared, its return was already the cell's VSS port (node 0 here), and it
* is an AC short to ground in both placements -- so DC operating points, .ac
* transfers and transients are all identical to the pre-#174 deck. The point
* of the move is that the idealization is now visible at the interface and a
* real reference (a bandgap block, or the Chipalooza Challenge #5 harness's
* bandgap-referenced bias-voltage slot) can drive it without editing the
* schematic. One source serves every DUT instance in this deck: an ideal
* source has zero output impedance, so instances cannot interact through it.
Vref VREF 0 DC 1.2

Xdut_en VIN_EN VOUT_EN VIN_EN 0 LOOP_EN LOOP_EN VREF ldo_core

Vamm_dis VIN VIN_DIS 0
Xdut_dis VIN_DIS VOUT_DIS 0 0 LOOP_DIS LOOP_DIS VREF ldo_core

Vamm_full VIN VIN_FULL 0
Xdut_full VIN_FULL VOUT_FULL VIN_FULL 0 LOOP_FULL LOOP_FULL VREF ldo_core

* --- Compliance-limited load sink on the _full instance (#46) -----------
* Vilc carries the COMMANDED load current as a number of volts (1 V == 1 A).
* It is a control node only and conducts no circuit current. Bload_full
* draws that current out of VOUT_FULL through the 0 V ammeter Vlmeas_full,
* scaled by a compliance factor that is 1 for VOUT_FULL well above ground
* and 0 at or below it:
*     f(VOUT_FULL) = 0.5 * (1 + tanh((VOUT_FULL - 0.2) / 0.05))
* At VOUT_FULL >= 1.0 V, 1 - f < 1.3e-14 (and df/dVOUT_FULL < 5.1e-13 per
* volt, i.e. under 2.6e-14 S of small-signal conductance at 50 mA), so the
* sink is an ideal 50 mA current sink to well past double precision -- and
* the bound tightens by another 14 orders of magnitude at the ~1.8 V this
* instance actually regulates to. iload_full_ma below
* measures the delivered current so that stays true rather than being
* assumed. That measurement matters more here than anywhere else, because
* iq_full_ua subtracts the injected 50 mA back out: if the sink ever
* delivered less than it was commanded, the subtraction would silently
* fabricate a negative Iq.
*
* What the bound removes is the *unphysical* branch of an ideal sink. An
* ideal sink demands its current at any terminal voltage, including tens of
* volts BELOW ground, where the only thing that can supply it is
* forward-biased substrate junctions inside the PDK device models. That is
* a genuine second DC solution of this deck, not a convergence failure, and
* it is what made iq_full_ua non-physical (#40, #46). Only _full has a load
* sink, so only _full introduces that second solution -- but all three
* instances are solved by ONE Newton iteration over ONE matrix, so it drags
* its deck-mates with it. Hand-checked at tt_27c_3.30v (#46): with the old
* ideal sink, vout_full = -28.65 V and iq_full_ua = -7.79 uA, and the _en
* instance is off the physical root too (vout_en = 1.014 V with
* xdut_en.fb = 0.677 V, nowhere near the 1.2 V VREF it must regulate to,
* reporting iq_en_ua = 17.44 uA). With this sink the same corner gives
* vout_full = vout_en = 1.79945 V, xdut_en.fb = 1.19964 V, iq_en_ua = 13.78
* uA. No real load sinks current from a rail below its own ground, so
* bounding the sink at 0 V deletes that solution instead of hiding it. See
* sim/harness/README.md, "Compliance-limited load sinks".
*
* What the bound does NOT delete (#304). It deletes the SINK-SUSTAINED
* root above -- the one the sink's own demand holds below ground. Below
* the knee the sink is exactly 0 A and 0 S (f underflows to 0.0 in double
* for VOUT_FULL <= -0.753 V), so the load network is absent from the DC
* equations there and anything the solver reports at a sub-ground
* VOUT_FULL with i(vlmeas_full) = 0 is beyond the bound's reach by
* construction -- no knee or softness can delete it, because the sink has
* no term left to remove. vout_full_v and iload_full_ma in tb.json are
* what catch that class, and read together they tell the two apart: the
* commanded current at a sub-ground point is the sink-sustained root,
* zero delivered current is a state the bound never reached. Do not
* retune the knee against a failing corner and do not add a load-side
* sub-ground clamp -- both were measured and ruled out. See
* sim/harness/README.md, "What the bound cannot reach".
Vilc ILC 0 DC 50m
@BLOAD_FULL@
Vlmeas_full NLOAD_FULL 0 DC 0
