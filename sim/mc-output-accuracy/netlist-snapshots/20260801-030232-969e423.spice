* Frozen netlist snapshot for record 20260801-030232-969e423
* This is a verbatim copy taken at record time. Do not edit.

* ======================================================================
* included design cell : design/netlist/ldo_core.spice
* sha256               : 0245314b5b4725332cd6565726354095a046337487847137ed70bac6b9ec6e24
* ======================================================================
* ldo_core -- generated by design/netlist.py from design/ldo_core.sch
* Do not edit: edit the schematic and re-run the export.
** sch_path: design/ldo_core.sch
.subckt ldo_core VIN VOUT EN VSS ERRAMP_OUT PASS_GATE
*.PININFO VIN:B VOUT:B EN:I VSS:B ERRAMP_OUT:O PASS_GATE:I
XMpass VOUT PASS_GATE VIN VIN pfet_03v3 L=0.28u W=2000u nf=40 ad='int((nf+1)/2) * W/nf * 0.18u' as='int((nf+2)/2) * W/nf * 0.18u' pd='2*int((nf+1)/2) * (W/nf + 0.18u)'
+ ps='2*int((nf+2)/2) * (W/nf + 0.18u)' nrd='0.18u / W' nrs='0.18u / W' sa=0 sb=0 sd=0 m=1
XMen PASS_GATE EN VIN VIN pfet_03v3 L=0.28u W=50u nf=2 ad='int((nf+1)/2) * W/nf * 0.18u' as='int((nf+2)/2) * W/nf * 0.18u' pd='2*int((nf+1)/2) * (W/nf + 0.18u)'
+ ps='2*int((nf+2)/2) * (W/nf + 0.18u)' nrd='0.18u / W' nrs='0.18u / W' sa=0 sb=0 sd=0 m=1
Rtop VOUT FB 300k m=1
Rbot FB VSS 600k m=1
Vref1 VREF VSS 1.2
Xerramp FB VREF ERRAMP_OUT VIN VSS error_amp
.ends

* expanding   symbol:  error_amp.sym # of pins=5
** sym_path: design/error_amp.sym
** sch_path: design/error_amp.sch
.subckt error_amp INP INN OUT VDD VSS
*.PININFO INP:I INN:I OUT:O VDD:B VSS:B
XRbias NBIAS VDD VSS ppolyf_u_1k r_width=1u r_length=1000u m=1
XMB1 NBIAS NBIAS VSS VSS nfet_03v3 L=4u W=6u nf=1 ad='int((nf+1)/2) * W/nf * 0.18u' as='int((nf+2)/2) * W/nf * 0.18u' pd='2*int((nf+1)/2) * (W/nf + 0.18u)'
+ ps='2*int((nf+2)/2) * (W/nf + 0.18u)' nrd='0.18u / W' nrs='0.18u / W' sa=0 sb=0 sd=0 m=1
XMTAIL TAIL NBIAS VSS VSS nfet_03v3 L=4u W=6u nf=1 ad='int((nf+1)/2) * W/nf * 0.18u' as='int((nf+2)/2) * W/nf * 0.18u' pd='2*int((nf+1)/2) * (W/nf + 0.18u)'
+ ps='2*int((nf+2)/2) * (W/nf + 0.18u)' nrd='0.18u / W' nrs='0.18u / W' sa=0 sb=0 sd=0 m=1
XMIN1 ND INN TAIL VSS nfet_03v3 L=6u W=60u nf=6 ad='int((nf+1)/2) * W/nf * 0.18u' as='int((nf+2)/2) * W/nf * 0.18u' pd='2*int((nf+1)/2) * (W/nf + 0.18u)'
+ ps='2*int((nf+2)/2) * (W/nf + 0.18u)' nrd='0.18u / W' nrs='0.18u / W' sa=0 sb=0 sd=0 m=1
XMIN2 N1 INP TAIL VSS nfet_03v3 L=6u W=60u nf=6 ad='int((nf+1)/2) * W/nf * 0.18u' as='int((nf+2)/2) * W/nf * 0.18u' pd='2*int((nf+1)/2) * (W/nf + 0.18u)'
+ ps='2*int((nf+2)/2) * (W/nf + 0.18u)' nrd='0.18u / W' nrs='0.18u / W' sa=0 sb=0 sd=0 m=1
XMLD1 ND ND VDD VDD pfet_03v3 L=8u W=8u nf=1 ad='int((nf+1)/2) * W/nf * 0.18u' as='int((nf+2)/2) * W/nf * 0.18u' pd='2*int((nf+1)/2) * (W/nf + 0.18u)'
+ ps='2*int((nf+2)/2) * (W/nf + 0.18u)' nrd='0.18u / W' nrs='0.18u / W' sa=0 sb=0 sd=0 m=1
XMLD2 N1 ND VDD VDD pfet_03v3 L=8u W=8u nf=1 ad='int((nf+1)/2) * W/nf * 0.18u' as='int((nf+2)/2) * W/nf * 0.18u' pd='2*int((nf+1)/2) * (W/nf + 0.18u)'
+ ps='2*int((nf+2)/2) * (W/nf + 0.18u)' nrd='0.18u / W' nrs='0.18u / W' sa=0 sb=0 sd=0 m=1
XRz NZ N1 VSS ppolyf_u r_width=1u r_length=109u m=1
XCc NZ OUT cap_mim_2f0_m2m3_noshield c_width=39u c_length=39u m=1
XM2P OUT N1 VDD VDD pfet_03v3 L=2u W=150u nf=15 ad='int((nf+1)/2) * W/nf * 0.18u' as='int((nf+2)/2) * W/nf * 0.18u' pd='2*int((nf+1)/2) * (W/nf + 0.18u)'
+ ps='2*int((nf+2)/2) * (W/nf + 0.18u)' nrd='0.18u / W' nrs='0.18u / W' sa=0 sb=0 sd=0 m=1
XM2N OUT NBIAS VSS VSS nfet_03v3 L=4u W=10u nf=1 ad='int((nf+1)/2) * W/nf * 0.18u' as='int((nf+2)/2) * W/nf * 0.18u' pd='2*int((nf+1)/2) * (W/nf + 0.18u)'
+ ps='2*int((nf+2)/2) * (W/nf + 0.18u)' nrd='0.18u / W' nrs='0.18u / W' sa=0 sb=0 sd=0 m=1
.ends

* ======================================================================
* testbench fragment   : sim/mc-output-accuracy/testbench/tb_mc_output_accuracy.spice
* sha256               : b32bc6a6668e29266f75d80b09cb9d5092dbc77745e92bcb211805f2469a814b
* ======================================================================
* tb_mc_output_accuracy -- Monte Carlo device-mismatch spread of the CLOSED-LOOP
* LDO output voltage (design/ldo_core.sch + design/error_amp.sch, issue #13).
*
* Netlist FRAGMENT. The harness supplies the title, the gf180mcu model
* .include, the corner .lib sections, .temp, the .control block (including the
* Monte Carlo loop, which lives in tb.json's "analyses" list) and .end, and it
* emits the .include of design/netlist/ldo_core.spice from this testbench's
* tb.json "includes" list. Harness-supplied parameters: vdd_val, vdd_nom,
* temp_c.
*
* ---------------------------------------------------------------------------
* What is Monte-Carlo'd, and what deliberately is NOT
* ---------------------------------------------------------------------------
* sw_stat_mismatch = 1 / sw_stat_global = 0 is intra-die LOCAL MISMATCH only --
* the thing a matched pair actually sees. Every FET in the loop (the error
* amp's input pair MIN1/MIN2, its mirror load MLD1/MLD2, the tail and bias
* devices, the second stage, and the pass device) carries the PDK's per-
* instance `delvto = mis_vth*sw_stat_mismatch` / `mulu0 = 1-mis_k*...` terms,
* redrawn on every `mc_source`. Global (die-to-die) spread is switched OFF on
* purpose: sim/devchar/CONCLUSIONS.md S2 measured it to be perfectly
* common-mode across a matched pair, so it moves neither the divider ratio nor
* the amplifier offset -- it would only add simulation noise to a mismatch
* claim.
*
* THE FEEDBACK DIVIDER IS NOT MONTE-CARLO'D AND CANNOT BE. Two independent
* reasons, both of which have to be stated or the sigma below reads as if it
* covered the divider:
*
*   1. ldo_core's divider is drawn as IDEAL SPICE resistors (`Rtop VOUT FB
*      300k` / `Rbot FB VSS 600k` in design/netlist/ldo_core.spice), which
*      carry no statistical model of any kind.
*   2. Even swapping them for the PDK subcircuits would not help: this PDK's
*      resistor cards hard-code `mis_r = 0` (the agauss() line is commented out
*      in the model file) and the high-sheet ppolyf_u_*k flavours carry no
*      mismatch term at all -- a matched pair returns bit-identical values over
*      200 MC runs (sim/devchar/CONCLUSIONS.md S2).
*
* A deck that "ran MC on the divider" against these models would report
* sigma = 0 and silently understate output-accuracy risk. design/error_amp.md
* S3.2 therefore carries the divider term as a fixed, hand-budgeted 3.36 mV
* (3 sigma) assumption, RSS'd onto this deck's result in
* sim/mc-output-accuracy/README.md. It is not, and must not be, a simulated
* number.
*
* This deck proves the divider is inert rather than assuming it: it measures
* VOUT and FB on the same instance in the same solve and reports
* `divider_exact_uv` = max |dVOUT - 1.5*dFB| over every sample. The divider
* sits between those two nodes, so any mismatch in it breaks the identity;
* pinning the residual below 1 uV is the in-situ statement that this run's
* sigma is the amplifier's alone and that S3.2's separate hand-budgeted term
* is additive rather than double-counted.
*
* Conversely, a NONZERO sigma is by itself the proof that FET mismatch is
* live: a DC operating point is deterministic, so with the statistical
* switches off every sample would be bit-identical and sigma would be exactly
* zero. tb.json puts a MINIMUM on sigma_mv for that reason -- the PDK's
* design.ngspice defaults sw_stat_mismatch = 0 and the harness includes it
* AFTER its own .param block, so the re-assertion below is load-bearing and a
* regression in it must fail loudly instead of reporting a flawless part.
*
* ---------------------------------------------------------------------------
* Why the CLOSED loop and not an amp-level offset servo
* ---------------------------------------------------------------------------
* The claim under test is the ratified output-accuracy row (1.8 V +/-2 %),
* which is an OUTPUT-referred, closed-loop property. Measuring V(VOUT)
* directly means the 1/beta = 1.5 offset gain-up of design/error_amp.md S3 is
* exercised by the circuit rather than applied by hand, and the amplifier's
* systematic offset and the per-corner line-regulation shift land in the same
* distribution's MEAN where the budget puts them (deterministic terms), while
* mismatch lands in its SIGMA (statistical term). Both are reported per corner
* so the two budget classes never get conflated.
*
* The amplifier's input-referred offset -- the quantity design/error_amp.md
* S3.1 predicts at 3 sigma <= 2.33 mV -- is the same distribution referred
* back through the (exactly verified) divider ratio, since in closed loop the
* loop forces FB onto VREF to within the amplifier's own offset: DC loop gain
* is 110-115 dB (design/error_amp.md S6), i.e. the residual loop error is
* sub-microvolt.
*
* ---------------------------------------------------------------------------
* Why 25 copies of the DUT per solve
* ---------------------------------------------------------------------------
* Each `mc_source` redraws every agauss() parameter in the deck, so N
* independent copies of ldo_core in one deck yield N independent mismatch
* samples per solve. 25 copies x 40 redraws = 1000 samples per PVT point. The
* copies share only the ideal VIN and EN sources and are otherwise
* electrically disjoint (own load, own output network, own internal 1.2 V
* reference), so they do not interact.
*
* The reason to batch this way is EVIDENCE SIZE, not speed: ngspice reprints
* its circuit/analysis banner on every re-source, which costs ~260 bytes per
* redraw. At one sample per redraw a 1000-sample corner log is ~290 kB and the
* 81-point matrix would commit ~23 MB of banner noise; batching 25 samples per
* redraw brings the same 81,000 samples down to ~2 MB, most of which is then
* the per-sample data itself. Solve time is unchanged -- it scales with
* samples, not with redraws.
*
* ---------------------------------------------------------------------------
* Operating point
* ---------------------------------------------------------------------------
* 1 mA load, the light-load point README note 1 makes binding for the
* accuracy-class rows. The load is the same 1.8 kOhm resistor
* sim/op-point-sanity uses, not an ideal current sink: a sink leaves the DC
* operating point unbounded from below and ngspice fails to converge on a
* noticeable fraction of the Monte Carlo samples (dynamic gmin, true gmin and
* source stepping all fail), which would silently poison the distribution with
* garbage samples. With a resistor the load current does follow the output
* error, but only by dV/1.8k: a 3 mV output error moves the load by 1.7 uA out
* of 1 mA, whose load-regulation contribution is ~4e-4 mV against the ratified
* < 1 % over 49 mA -- three orders of magnitude below the mismatch sigma being
* measured. Load regulation over 1-50 mA is a separate, deterministic 18 mV
* allowance in design/error_amp.md S3, verified by #12, and is deliberately
* not re-derived here.
*
* The output network is the DR-0001 nominal (1 uF, 100 mOhm ESR). It is
* irrelevant to a DC operating point and is present only so this deck's DUT
* environment matches the other ldo_core benches.
*
* ---------------------------------------------------------------------------
* Why the 'mos' corner-set (tt/ff/ss/fs/sf) and not 'full'
* ---------------------------------------------------------------------------
* tb.json requests --corner-set mos (5 corners), not the 9-corner 'full' set
* sim/harness/corners.py also defines. That set adds res_ff/res_ss (resistor
* sheet-rho skew) and bjt_ff/bjt_ss (BJT skew) on top of the five MOS corners,
* and its own docstring says those extra four are "for claims where that
* matters (e.g. divider-accuracy or reference claims)" -- neither of which
* this deck is:
*
*   - bjt_ff/bjt_ss: design/netlist/ldo_core.spice instantiates zero BJTs
*     (XMpass/XMen/XMB1/XMTAIL/XMIN1/XMIN2/XMLD1/XMLD2/XM2P/XM2N are all
*     nfet_03v3/pfet_03v3; the only other devices are two poly resistors and
*     a MiM cap). A BJT-skew corner is a no-op on this circuit by
*     construction, not merely low-impact.
*   - res_ff/res_ss: the feedback divider (Rtop/Rbot in ldo_core.spice) is
*     drawn as IDEAL spice resistors, which carry no corner sensitivity at
*     all -- a resistor-skew corner cannot move the divider ratio here either
*     way (this is the same "ideal R" fact S3.2's fixed-assumption paragraph
*     above already relies on). The only PDK poly resistors in the circuit
*     are the bias-generator reference (XRbias) and the Miller-compensation
*     zero resistor (XRz); a resistor-skew corner shifts their value and
*     therefore the deterministic bias point / compensation zero, not the
*     FET local-mismatch statistic this deck exists to measure. That is a
*     legitimate but SEPARATE deterministic bias-sensitivity question for a
*     future targeted testbench, not a gap in this record's sigma claim.
*
* mos x 3 temps x 3 supplies is still 45 full-factorial PVT points -- the
* full CLAUDE.md-mandated temperature and supply axes, just without the two
* corner families this claim cannot be sensitive to. sim/harness's own
* matrix-conformance check (>=3 process corners, full temp/supply axes)
* accepts this as a complete PVT matrix for that reason.

* ---- the PDK statistical switches ------------------------------------------
* MUST be re-asserted here, AFTER the harness's .include of the PDK's
* design.ngspice: that file's own `.param sw_stat_mismatch = 0` default would
* otherwise be the last definition to win and every sample would come back
* identical.
.param sw_stat_mismatch=1
.param sw_stat_global=0

* ---- stimulus --------------------------------------------------------------
Vin  VIN 0 dc {vdd_val}
Ven  EN  0 dc {vdd_val}

* ---- DUT: 25 independent copies of ldo_core --------------------------------
* Port order (design/ldo_core.sym): VIN VOUT EN VSS ERRAMP_OUT PASS_GATE.
* ERRAMP_OUT/PASS_GATE are ldo_core's loop-break ports; tie them together for
* normal closed-loop operation, exactly as sim/op-point-sanity does.
X1  VIN vo1  EN 0 loop1  loop1  ldo_core
X2  VIN vo2  EN 0 loop2  loop2  ldo_core
X3  VIN vo3  EN 0 loop3  loop3  ldo_core
X4  VIN vo4  EN 0 loop4  loop4  ldo_core
X5  VIN vo5  EN 0 loop5  loop5  ldo_core
X6  VIN vo6  EN 0 loop6  loop6  ldo_core
X7  VIN vo7  EN 0 loop7  loop7  ldo_core
X8  VIN vo8  EN 0 loop8  loop8  ldo_core
X9  VIN vo9  EN 0 loop9  loop9  ldo_core
X10 VIN vo10 EN 0 loop10 loop10 ldo_core
X11 VIN vo11 EN 0 loop11 loop11 ldo_core
X12 VIN vo12 EN 0 loop12 loop12 ldo_core
X13 VIN vo13 EN 0 loop13 loop13 ldo_core
X14 VIN vo14 EN 0 loop14 loop14 ldo_core
X15 VIN vo15 EN 0 loop15 loop15 ldo_core
X16 VIN vo16 EN 0 loop16 loop16 ldo_core
X17 VIN vo17 EN 0 loop17 loop17 ldo_core
X18 VIN vo18 EN 0 loop18 loop18 ldo_core
X19 VIN vo19 EN 0 loop19 loop19 ldo_core
X20 VIN vo20 EN 0 loop20 loop20 ldo_core
X21 VIN vo21 EN 0 loop21 loop21 ldo_core
X22 VIN vo22 EN 0 loop22 loop22 ldo_core
X23 VIN vo23 EN 0 loop23 loop23 ldo_core
X24 VIN vo24 EN 0 loop24 loop24 ldo_core
X25 VIN vo25 EN 0 loop25 loop25 ldo_core

* ---- load and output network, one per copy ---------------------------------
Rload1  vo1  0 1.8k
Resr1   vo1  nesr1  0.1
Cout1   nesr1  0 1u
Rload2  vo2  0 1.8k
Resr2   vo2  nesr2  0.1
Cout2   nesr2  0 1u
Rload3  vo3  0 1.8k
Resr3   vo3  nesr3  0.1
Cout3   nesr3  0 1u
Rload4  vo4  0 1.8k
Resr4   vo4  nesr4  0.1
Cout4   nesr4  0 1u
Rload5  vo5  0 1.8k
Resr5   vo5  nesr5  0.1
Cout5   nesr5  0 1u
Rload6  vo6  0 1.8k
Resr6   vo6  nesr6  0.1
Cout6   nesr6  0 1u
Rload7  vo7  0 1.8k
Resr7   vo7  nesr7  0.1
Cout7   nesr7  0 1u
Rload8  vo8  0 1.8k
Resr8   vo8  nesr8  0.1
Cout8   nesr8  0 1u
Rload9  vo9  0 1.8k
Resr9   vo9  nesr9  0.1
Cout9   nesr9  0 1u
Rload10 vo10 0 1.8k
Resr10  vo10 nesr10 0.1
Cout10  nesr10 0 1u
Rload11 vo11 0 1.8k
Resr11  vo11 nesr11 0.1
Cout11  nesr11 0 1u
Rload12 vo12 0 1.8k
Resr12  vo12 nesr12 0.1
Cout12  nesr12 0 1u
Rload13 vo13 0 1.8k
Resr13  vo13 nesr13 0.1
Cout13  nesr13 0 1u
Rload14 vo14 0 1.8k
Resr14  vo14 nesr14 0.1
Cout14  nesr14 0 1u
Rload15 vo15 0 1.8k
Resr15  vo15 nesr15 0.1
Cout15  nesr15 0 1u
Rload16 vo16 0 1.8k
Resr16  vo16 nesr16 0.1
Cout16  nesr16 0 1u
Rload17 vo17 0 1.8k
Resr17  vo17 nesr17 0.1
Cout17  nesr17 0 1u
Rload18 vo18 0 1.8k
Resr18  vo18 nesr18 0.1
Cout18  nesr18 0 1u
Rload19 vo19 0 1.8k
Resr19  vo19 nesr19 0.1
Cout19  nesr19 0 1u
Rload20 vo20 0 1.8k
Resr20  vo20 nesr20 0.1
Cout20  nesr20 0 1u
Rload21 vo21 0 1.8k
Resr21  vo21 nesr21 0.1
Cout21  nesr21 0 1u
Rload22 vo22 0 1.8k
Resr22  vo22 nesr22 0.1
Cout22  nesr22 0 1u
Rload23 vo23 0 1.8k
Resr23  vo23 nesr23 0.1
Cout23  nesr23 0 1u
Rload24 vo24 0 1.8k
Resr24  vo24 nesr24 0.1
Cout24  nesr24 0 1u
Rload25 vo25 0 1.8k
Resr25  vo25 nesr25 0.1
Cout25  nesr25 0 1u
