* load-regulation -- stimulus fragment for ldo_core (issue #12)
*
* Load regulation over the ratified 0-50 mA window (README.md Target
* specification, "Load reg (0-50 mA)" row): a single in-run .dc sweep of
* the commanded load current from 1 mA to 50 mA (2-point sweep, endpoints
* only) captures both ends within one ngspice invocation per PVT point --
* see tb.json's "analyses" field. EN is tied to VIN at instantiation
* (enabled).
Vsup VIN 0 DC {vdd_val}
* --- Reference (issue #174 / DR-0021) ------------------------------------
* VREF is a TOP-LEVEL PORT of ldo_core as of #174; it used to be an internal
* net driven by Vref1, an ideal 1.2 V vsource instantiated INSIDE the
* subcircuit. That source is deleted from design/ldo_core.sch and reappears
* here, unchanged, at deck level. This is an electrical no-op by
* construction: an ideal vsource is an ideal vsource wherever it is
* declared, its return was already the cell's VSS port (node 0 here), and it
* is an AC short to ground in both placements -- so DC operating points, .ac
* transfers and transients are all identical to the pre-#174 deck. The point
* of the move is that the idealization is now visible at the interface and a
* real reference (a bandgap block, or the Chipalooza Challenge #5 harness's
* bandgap-referenced bias-voltage slot) can drive it without editing the
* schematic. One source serves every DUT instance in this deck: an ideal
* source has zero output impedance, so instances cannot interact through it.
Vref VREF 0 DC 1.2

Xdut VIN VOUT VIN 0 LOOP LOOP VREF ldo_core

* --- Compliance-limited load sink (#46) --------------------------------
* Vilc carries the COMMANDED load current as a number of volts (1 V == 1 A).
* It is a control node only -- it conducts no circuit current -- which is
* what lets .dc sweep the load with a voltage source. Bload draws that
* current out of VOUT through the 0 V ammeter Vlmeas, scaled by a
* compliance factor that is 1 for VOUT well above ground and 0 at or below
* it:
*     f(VOUT) = 0.5 * (1 + tanh((VOUT - 0.2) / 0.05))
* At VOUT >= 1.0 V, 1 - f < 1.3e-14 and df/dVOUT < 5.1e-13 per volt (so the
* sink's own small-signal conductance is under 2.6e-14 S even at 50 mA), and
* at the ~1.8 V this design actually regulates to both are smaller by
* another 14 orders of magnitude. At every operating point this experiment
* reports, the sink is therefore an ideal current sink to well past double
* precision -- and i(Vlmeas) is measured and checked against the commanded
* current so that stays true rather than being assumed.
*
* What the bound removes is the *unphysical* branch of an ideal sink. An
* ideal sink demands its current at any terminal voltage, including tens of
* volts BELOW ground, where the only thing that can supply it is
* forward-biased substrate junctions inside the PDK device models. That is
* a genuine second DC solution of this deck, not a convergence failure, and
* a cold Newton-Raphson start reached it at 41 of 45 PVT points (#40, #46).
* No real load sinks current from a rail below its own ground, so bounding
* the sink at 0 V deletes that solution instead of hiding it. See
* sim/harness/README.md, "Compliance-limited load sinks".
*
* What the bound does NOT delete (#304). It deletes the SINK-SUSTAINED
* root above -- the one the sink's own demand holds below ground. Below
* the knee the sink is exactly 0 A and 0 S (f underflows to 0.0 in double
* for VOUT <= -0.753 V), so the load network is absent from the DC
* equations there and anything the solver reports at a sub-ground VOUT
* with i(vlmeas) = 0 is beyond the bound's reach by construction -- no
* knee or softness can delete it, because the sink has no term left to
* remove. vout_1ma / vout_50ma and iload_1ma_ma / iload_50ma_ma in
* tb.json are what catch that class, and read together they tell the two
* apart: the commanded current at a sub-ground point is the
* sink-sustained root, zero delivered current is a state the bound never
* reached. Do not retune the knee against a failing corner and do not add
* a load-side sub-ground clamp -- both were measured and ruled out. See
* sim/harness/README.md, "What the bound cannot reach".
Vilc ILC 0 DC 1m
Bload VOUT NLOAD I = 'v(ilc) * 0.5 * (1 + tanh((v(vout) - 0.2) / 0.05))'
Vlmeas NLOAD 0 DC 0

Resr VOUT n_esr 0.1
Cout n_esr 0 1u
