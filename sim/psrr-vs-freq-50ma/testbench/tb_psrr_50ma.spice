* psrr-vs-freq-50ma -- stimulus fragment for ldo_core (issue #99)
*
* The full-load (50 mA) half of the ratified PSRR row. Same topology, same
* stimulus and same output network as sim/psrr-vs-freq/testbench/tb_psrr.spice
* -- the ONLY circuit difference is the commanded load current (Vilc: 50 mA
* here, 1 mA there).
*
* PSRR vs frequency (README.md Target specification, "PSRR" row; DR-0004
* amendment A7): >50dB @ 1kHz and >20dB @ 100kHz, C_eff=1uF nominal. A small
* -signal AC source rides on Vin (Vsup ... AC 1); PSRR(f) = -Vout(f)/Vin(f)
* in dB = -vdb(vout) since the 1V AC stimulus is 0dB.
*
* Why a second experiment slug instead of a second load point inside
* tb_psrr.spice: the harness runs one manifest per slug and the two DC bias
* points cannot share one deck. Combining them via ngspice's "alter" between
* two .ac runs was tried and rejected in #12/#46 -- ngspice's per-.meas result
* vectors (and any "let" derived from them) go out of scope as soon as a later
* analysis becomes the current plot, so the second .ac silently re-reports the
* first .ac's captured values instead of erroring. A sibling slug (the pattern
* sim/dropout-vs-load/ already uses for its own single fixed load point) keeps
* each load condition on its own deck, its own full PVT sweep, its own checks
* and its own record with its own separate verdict -- which is what the
* ratified row's two load conditions need.
Vsup VIN 0 DC {vdd_val} AC 1
* --- Reference (issue #174 / DR-0021) ------------------------------------
* VREF is a TOP-LEVEL PORT of ldo_core as of #174; it used to be an internal
* net driven by Vref1, an ideal 1.2 V vsource instantiated INSIDE the
* subcircuit. That source is deleted from design/ldo_core.sch and reappears
* here, unchanged, at deck level. This is an electrical no-op by
* construction: an ideal vsource is an ideal vsource wherever it is
* declared, its return was already the cell's VSS port (node 0 here), and it
* is an AC short to ground in both placements -- so DC operating points, .ac
* transfers and transients are all identical to the pre-#174 deck. The point
* of the move is that the idealization is now visible at the interface and a
* real reference (a bandgap block, or the Chipalooza Challenge #5 harness's
* bandgap-referenced bias-voltage slot) can drive it without editing the
* schematic. One source serves every DUT instance in this deck: an ideal
* source has zero output impedance, so instances cannot interact through it.
Vref VREF 0 DC 1.2

Xdut VIN VOUT VIN 0 LOOP LOOP VREF ldo_core

* --- Compliance-limited load sink (#46) --------------------------------
* Vilc carries the COMMANDED load current as a number of volts (1 V == 1 A).
* It is a control node only and conducts no circuit current. Bload draws
* that current out of VOUT through the 0 V ammeter Vlmeas, scaled by a
* compliance factor that is 1 for VOUT well above ground and 0 at or below
* it:
*     f(VOUT) = 0.5 * (1 + tanh((VOUT - 0.2) / 0.05))
* At VOUT >= 1.0 V, 1 - f < 1.3e-14, so the DC sink is ideal to well past
* double precision; and -- what matters for an AC measurement -- the
* small-signal conductance the sink presents at the operating point is
* df/dVOUT * v(ilc) < 2.6e-14 S at 50 mA (and ~3e-28 S at the ~1.8 V this
* design actually regulates to), i.e. an open circuit at AC exactly like the
* ideal sink it replaces. dc_vout_v / dc_iload_ma below read the .op plot
* directly so both properties are checked at every corner instead of
* assumed.
*
* The "op" entry in tb.json's analyses list exists for that reporting, not
* to steer the .ac: ngspice's ac command solves its own operating point.
*
* What the bound removes is the *unphysical* branch of an ideal sink. An
* ideal sink demands its current at any terminal voltage, including tens of
* volts BELOW ground, where the only thing that can supply it is
* forward-biased substrate junctions inside the PDK device models. That is
* a genuine second solution for the operating point this .ac linearizes
* around, not a convergence failure, and a cold Newton-Raphson start reached
* it at most PVT points before #46 bounded the sink (#40, #46) -- which made
* the small-signal PSRR that followed meaningless. That risk is strictly
* larger at 50 mA than at 1 mA (a bigger demanded current biases the
* unphysical root harder), which is why dc_vout_v / dc_iload_ma are gated at
* every corner here too. See sim/harness/README.md, "Compliance-limited load
* sinks".
*
* What the bound does NOT delete (#304). It deletes the SINK-SUSTAINED
* root above -- the one the sink's own demand holds below ground. Below
* the knee the sink is exactly 0 A and 0 S (f underflows to 0.0 in double
* for VOUT <= -0.753 V), so the load network is absent from the DC
* equations there and anything the solver reports at a sub-ground VOUT
* with i(vlmeas) = 0 is beyond the bound's reach by construction -- no
* knee or softness can delete it, because the sink has no term left to
* remove. The sibling 1 mA deck hit exactly that in record
* 20260923-084323-a6c95f8 (dc_vout_v = -64.75 V, dc_iload_ma = 0) on the
* DUT netlist of the day; #304 measured it and found a false convergence
* on the continuation ladder's first rung, not a second solution.
* dc_vout_v and dc_iload_ma are what catch that class, and read together
* they tell the two apart: the commanded current at a sub-ground point is
* the sink-sustained root, zero delivered current is a state the bound
* never reached. Do not retune the knee against a failing corner and do
* not add a load-side sub-ground clamp -- both were measured and ruled
* out. See sim/harness/README.md, "What the bound cannot reach".
*
* Supply gate on the sink (#478). A cold .op or .ac solve of this deck at
* ss / -40 C / 2.97 V finds no DC point by gmin stepping (dynamic and true
* both fail) and, with the 50 mA sink already on at every source level,
* falls through to ngspice's pseudo-transient fallback, which reports the
* pass-device-off state (Vout 0.145 V, 5.0 mA delivered) in BOTH the op and
* the ac request. A preceding .dc sweep of Vilc (the #472 fix for the
* load/line/dropout benches) does not help here: the .ac analysis re-solves
* its own operating point from a cold start and ignores the sweep. The
* continuation therefore has to live in the deck, where every cold solve
* sees it: the sink is multiplied by a second smooth gate on the supply,
*     g(VIN) = 0.5 * (1 + tanh((VIN - 2.0) / 0.05))
* so source stepping (which scales VIN and the commanded current together)
* brings the regulator up with no load and ramps the 50 mA in as VIN passes
* 2 V, i.e. it reaches the 50 mA point by continuation along the physical
* branch. The load is the same physical sink it was: a load on the VIN
* domain draws nothing without its supply. At the lowest supply this bench
* runs (2.97 V) 1 - g < 1e-16, the DC sink is ideal to the same precision
* as the Vout compliance factor, and dg/dVIN * Iload < 1e-15 S, an open
* circuit at AC. Nothing is seeded (no .nodeset/.ic, #308/#311); dc_vout_v
* and dc_iload_ma still read the .op plot at every corner.
Vilc ILC 0 DC 50m
Bload VOUT NLOAD I = 'v(ilc) * 0.5 * (1 + tanh((v(vout) - 0.2) / 0.05)) * 0.5 * (1 + tanh((v(vin) - 2.0) / 0.05))'
Vlmeas NLOAD 0 DC 0

Resr VOUT n_esr 0.1
Cout n_esr 0 1u
