* psrr-vs-freq-50ma -- stimulus fragment for ldo_core (issue #99)
*
* The full-load (50 mA) half of the ratified PSRR row. Same topology, same
* stimulus and same output network as sim/psrr-vs-freq/testbench/tb_psrr.spice
* -- the ONLY circuit difference is the commanded load current (Vilc: 50 mA
* here, 1 mA there).
*
* PSRR vs frequency (README.md Target specification, "PSRR" row; DR-0004
* amendment A7): >50dB @ 1kHz and >20dB @ 100kHz, C_eff=1uF nominal. A small
* -signal AC source rides on Vin (Vsup ... AC 1); PSRR(f) = -Vout(f)/Vin(f)
* in dB = -vdb(vout) since the 1V AC stimulus is 0dB.
*
* Why a second experiment slug instead of a second load point inside
* tb_psrr.spice: the harness runs one manifest per slug and the two DC bias
* points cannot share one deck. Combining them via ngspice's "alter" between
* two .ac runs was tried and rejected in #12/#46 -- ngspice's per-.meas result
* vectors (and any "let" derived from them) go out of scope as soon as a later
* analysis becomes the current plot, so the second .ac silently re-reports the
* first .ac's captured values instead of erroring. A sibling slug (the pattern
* sim/dropout-vs-load/ already uses for its own single fixed load point) keeps
* each load condition on its own deck, its own full PVT sweep, its own checks
* and its own record with its own separate verdict -- which is what the
* ratified row's two load conditions need.
Vsup VIN 0 DC {vdd_val} AC 1
Xdut VIN VOUT VIN 0 LOOP LOOP ldo_core

* --- Compliance-limited load sink (#46) --------------------------------
* Vilc carries the COMMANDED load current as a number of volts (1 V == 1 A).
* It is a control node only and conducts no circuit current. Bload draws
* that current out of VOUT through the 0 V ammeter Vlmeas, scaled by a
* compliance factor that is 1 for VOUT well above ground and 0 at or below
* it:
*     f(VOUT) = 0.5 * (1 + tanh((VOUT - 0.2) / 0.05))
* At VOUT >= 1.0 V, 1 - f < 1.3e-14, so the DC sink is ideal to well past
* double precision; and -- what matters for an AC measurement -- the
* small-signal conductance the sink presents at the operating point is
* df/dVOUT * v(ilc) < 2.6e-14 S at 50 mA (and ~3e-28 S at the ~1.8 V this
* design actually regulates to), i.e. an open circuit at AC exactly like the
* ideal sink it replaces. dc_vout_v / dc_iload_ma below read the .op plot
* directly so both properties are checked at every corner instead of
* assumed.
*
* The "op" entry in tb.json's analyses list exists for that reporting, not
* to steer the .ac: ngspice's ac command solves its own operating point.
*
* What the bound removes is the *unphysical* branch of an ideal sink. An
* ideal sink demands its current at any terminal voltage, including tens of
* volts BELOW ground, where the only thing that can supply it is
* forward-biased substrate junctions inside the PDK device models. That is
* a genuine second solution for the operating point this .ac linearizes
* around, not a convergence failure, and a cold Newton-Raphson start reached
* it at most PVT points before #46 bounded the sink (#40, #46) -- which made
* the small-signal PSRR that followed meaningless. That risk is strictly
* larger at 50 mA than at 1 mA (a bigger demanded current biases the
* unphysical root harder), which is why dc_vout_v / dc_iload_ma are gated at
* every corner here too. See sim/harness/README.md, "Compliance-limited load
* sinks".
Vilc ILC 0 DC 50m
Bload VOUT NLOAD I = 'v(ilc) * 0.5 * (1 + tanh((v(vout) - 0.2) / 0.05))'
Vlmeas NLOAD 0 DC 0

Resr VOUT n_esr 0.1
Cout n_esr 0 1u
