* Frozen netlist snapshot for record 20260802-065752-36e6984
* This is a verbatim copy taken at record time. Do not edit.

* ======================================================================
* included design cell : design/netlist/error_amp.spice
* sha256               : f47f8bb1ee3ed4192cf31efb787566bb9ffdb73012f6db48fcad0486b985cbc4
* ======================================================================
* error_amp -- generated by design/netlist.py from design/error_amp.sch
* Do not edit: edit the schematic and re-run the export.
** sch_path: design/error_amp.sch
.subckt error_amp INP INN OUT VDD VSS EN BG
*.PININFO INP:I INN:I OUT:O VDD:B VSS:B EN:I BG:B
XRbias NBIAS RBT VSS ppolyf_u_1k r_width=1u r_length=1000u m=1
XMB1 NBIAS NBIAS VSS VSS nfet_03v3 L=4u W=6u nf=1 ad='int((nf+1)/2) * W/nf * 0.18u' as='int((nf+2)/2) * W/nf * 0.18u' pd='2*int((nf+1)/2) * (W/nf + 0.18u)'
+ ps='2*int((nf+2)/2) * (W/nf + 0.18u)' nrd='0.18u / W' nrs='0.18u / W' sa=0 sb=0 sd=0 m=1
XMTAIL TAIL NBIAS VSS VSS nfet_03v3 L=4u W=6u nf=1 ad='int((nf+1)/2) * W/nf * 0.18u' as='int((nf+2)/2) * W/nf * 0.18u' pd='2*int((nf+1)/2) * (W/nf + 0.18u)'
+ ps='2*int((nf+2)/2) * (W/nf + 0.18u)' nrd='0.18u / W' nrs='0.18u / W' sa=0 sb=0 sd=0 m=1
XMIN1 ND INN TAIL VSS nfet_03v3 L=6u W=60u nf=6 ad='int((nf+1)/2) * W/nf * 0.18u' as='int((nf+2)/2) * W/nf * 0.18u' pd='2*int((nf+1)/2) * (W/nf + 0.18u)'
+ ps='2*int((nf+2)/2) * (W/nf + 0.18u)' nrd='0.18u / W' nrs='0.18u / W' sa=0 sb=0 sd=0 m=1
XMIN2 N1 INP TAIL VSS nfet_03v3 L=6u W=60u nf=6 ad='int((nf+1)/2) * W/nf * 0.18u' as='int((nf+2)/2) * W/nf * 0.18u' pd='2*int((nf+1)/2) * (W/nf + 0.18u)'
+ ps='2*int((nf+2)/2) * (W/nf + 0.18u)' nrd='0.18u / W' nrs='0.18u / W' sa=0 sb=0 sd=0 m=1
XMLD1 ND ND VDD VDD pfet_03v3 L=8u W=8u nf=1 ad='int((nf+1)/2) * W/nf * 0.18u' as='int((nf+2)/2) * W/nf * 0.18u' pd='2*int((nf+1)/2) * (W/nf + 0.18u)'
+ ps='2*int((nf+2)/2) * (W/nf + 0.18u)' nrd='0.18u / W' nrs='0.18u / W' sa=0 sb=0 sd=0 m=1
XMLD2 N1 ND VDD VDD pfet_03v3 L=8u W=8u nf=1 ad='int((nf+1)/2) * W/nf * 0.18u' as='int((nf+2)/2) * W/nf * 0.18u' pd='2*int((nf+1)/2) * (W/nf + 0.18u)'
+ ps='2*int((nf+2)/2) * (W/nf + 0.18u)' nrd='0.18u / W' nrs='0.18u / W' sa=0 sb=0 sd=0 m=1
XRz NZ N1 VSS ppolyf_u_1k r_width=1u r_length=6000u m=1
XCc NZ OUT cap_mim_2f0_m2m3_noshield c_width=49u c_length=49u m=1
XM2P BG N1 VDD VDD pfet_03v3 L=2u W=150u nf=15 ad='int((nf+1)/2) * W/nf * 0.18u' as='int((nf+2)/2) * W/nf * 0.18u' pd='2*int((nf+1)/2) * (W/nf + 0.18u)'
+ ps='2*int((nf+2)/2) * (W/nf + 0.18u)' nrd='0.18u / W' nrs='0.18u / W' sa=0 sb=0 sd=0 m=1
XM2N BG NBIAS VSS VSS nfet_03v3 L=4u W=4u nf=1 ad='int((nf+1)/2) * W/nf * 0.18u' as='int((nf+2)/2) * W/nf * 0.18u' pd='2*int((nf+1)/2) * (W/nf + 0.18u)'
+ ps='2*int((nf+2)/2) * (W/nf + 0.18u)' nrd='0.18u / W' nrs='0.18u / W' sa=0 sb=0 sd=0 m=1
XRbufb NBP N1 VSS ppolyf_u_1k r_width=1u r_length=5000u m=1
XMbufb OUT NBP VDD VDD pfet_03v3 L=2u W=200u nf=20 ad='int((nf+1)/2) * W/nf * 0.18u' as='int((nf+2)/2) * W/nf * 0.18u' pd='2*int((nf+1)/2) * (W/nf + 0.18u)'
+ ps='2*int((nf+2)/2) * (W/nf + 0.18u)' nrd='0.18u / W' nrs='0.18u / W' sa=0 sb=0 sd=0 m=1
XMbuf OUT BG VSS OUT pfet_03v3 L=1u W=150u nf=15 ad='int((nf+1)/2) * W/nf * 0.18u' as='int((nf+2)/2) * W/nf * 0.18u' pd='2*int((nf+1)/2) * (W/nf + 0.18u)'
+ ps='2*int((nf+2)/2) * (W/nf + 0.18u)' nrd='0.18u / W' nrs='0.18u / W' sa=0 sb=0 sd=0 m=1
XMpgn OUT NBIAS VSS VSS nfet_03v3 L=8u W=2u nf=1 ad='int((nf+1)/2) * W/nf * 0.18u' as='int((nf+2)/2) * W/nf * 0.18u' pd='2*int((nf+1)/2) * (W/nf + 0.18u)'
+ ps='2*int((nf+2)/2) * (W/nf + 0.18u)' nrd='0.18u / W' nrs='0.18u / W' sa=0 sb=0 sd=0 m=1
XMbg_pu BG EN VDD VDD pfet_03v3 L=0.5u W=4u nf=1 ad='int((nf+1)/2) * W/nf * 0.18u' as='int((nf+2)/2) * W/nf * 0.18u' pd='2*int((nf+1)/2) * (W/nf + 0.18u)'
+ ps='2*int((nf+2)/2) * (W/nf + 0.18u)' nrd='0.18u / W' nrs='0.18u / W' sa=0 sb=0 sd=0 m=1
XMinv_p ENB EN VDD VDD pfet_03v3 L=0.5u W=4u nf=1 ad='int((nf+1)/2) * W/nf * 0.18u' as='int((nf+2)/2) * W/nf * 0.18u' pd='2*int((nf+1)/2) * (W/nf + 0.18u)'
+ ps='2*int((nf+2)/2) * (W/nf + 0.18u)' nrd='0.18u / W' nrs='0.18u / W' sa=0 sb=0 sd=0 m=1
XMinv_n ENB EN VSS VSS nfet_03v3 L=0.5u W=2u nf=1 ad='int((nf+1)/2) * W/nf * 0.18u' as='int((nf+2)/2) * W/nf * 0.18u' pd='2*int((nf+1)/2) * (W/nf + 0.18u)'
+ ps='2*int((nf+2)/2) * (W/nf + 0.18u)' nrd='0.18u / W' nrs='0.18u / W' sa=0 sb=0 sd=0 m=1
XMbias_h RBT ENB VDD VDD pfet_03v3 L=0.5u W=20u nf=1 ad='int((nf+1)/2) * W/nf * 0.18u' as='int((nf+2)/2) * W/nf * 0.18u' pd='2*int((nf+1)/2) * (W/nf + 0.18u)'
+ ps='2*int((nf+2)/2) * (W/nf + 0.18u)' nrd='0.18u / W' nrs='0.18u / W' sa=0 sb=0 sd=0 m=1
XMnb_pd NBIAS ENB VSS VSS nfet_03v3 L=0.5u W=10u nf=1 ad='int((nf+1)/2) * W/nf * 0.18u' as='int((nf+2)/2) * W/nf * 0.18u' pd='2*int((nf+1)/2) * (W/nf + 0.18u)'
+ ps='2*int((nf+2)/2) * (W/nf + 0.18u)' nrd='0.18u / W' nrs='0.18u / W' sa=0 sb=0 sd=0 m=1
XMn1_pu N1 EN VDD VDD pfet_03v3 L=0.5u W=4u nf=1 ad='int((nf+1)/2) * W/nf * 0.18u' as='int((nf+2)/2) * W/nf * 0.18u' pd='2*int((nf+1)/2) * (W/nf + 0.18u)'
+ ps='2*int((nf+2)/2) * (W/nf + 0.18u)' nrd='0.18u / W' nrs='0.18u / W' sa=0 sb=0 sd=0 m=1
XMnd_pu ND EN VDD VDD pfet_03v3 L=0.5u W=4u nf=1 ad='int((nf+1)/2) * W/nf * 0.18u' as='int((nf+2)/2) * W/nf * 0.18u' pd='2*int((nf+1)/2) * (W/nf + 0.18u)'
+ ps='2*int((nf+2)/2) * (W/nf + 0.18u)' nrd='0.18u / W' nrs='0.18u / W' sa=0 sb=0 sd=0 m=1
.ends

* ======================================================================
* testbench fragment   : sim/amp-openloop/testbench/tb_amp_openloop.spice
* sha256               : d4cda6f2f740999208c8ad05ae7b9552d30e91e63fb50c0002fca9e508a17744
* ======================================================================
* tb_amp_openloop -- open-loop gain / UGBW / phase margin / systematic offset /
* Iq / output swing of the LDO error amplifier (design/error_amp.sch, #9).
*
* Netlist FRAGMENT. The harness supplies the title, the gf180mcu model
* .include, the corner .lib sections, .temp, the .control block and .end, and
* it emits the .include of design/netlist/error_amp.spice from this
* testbench's tb.json "includes" list. Harness-supplied parameters: vdd_val,
* vdd_nom, temp_c.
*
* Amp pinout is #8's ratified swap-in contract: INP INN OUT VDD VSS, with
* INP the NON-inverting input (wired to FB in ldo_core) and INN the
* inverting input (wired to VREF). Two pins have since been APPENDED to that
* contract without disturbing the first five: EN (#11) and BG (#55). BG is
* the class-AB buffer's internal gate node, exported so the soft-start and
* current-limit clamps can release the follower instead of fighting it; it is
* driven entirely from inside the cell, so each instance below simply gives it
* its own dangling node (bg1..bg5) and nothing about this bench's measurements
* changes.
*
* ---------------------------------------------------------------------------
* How the amplifier is broken open
* ---------------------------------------------------------------------------
* The transfer under test is INP -> OUT, which is NON-inverting (the loop's
* inversion lives in the PMOS pass device, not here), so the DC servo that
* holds the operating point has to close on INN, where the gain is negative.
*
*   Lfb (1 TH)  short at DC, open at AC -> the operating point is held by
*               real feedback while the AC path is broken.
*   Vls         level-shifts that feedback so the servo parks OUT at a chosen
*               operating point instead of at VCM.
*   Cref (1 F)  makes INN an AC ground, so the residual 1/(jwL) leakage of the
*               feedback path cannot re-close the loop at 0.1 Hz.
*
* The AC stimulus is the DC bias source on INP itself (dc {vcm} ac 1), so
* v(vg)/1 is the open-loop gain from the sensed feedback node -- exactly the
* transfer the LDO loop uses.
*
* The residual INN-INP difference the servo settles on IS the amplifier's
* input-referred *systematic* offset (matched devices, no mismatch). The
* random part is a hand budget from the measured Pelgrom A_VT; a mismatch
* Monte Carlo is a distribution claim and belongs to #13, not to a corner
* record. See design/error_amp.md.
*
* EN (sixth port, appended by issue #11): each instance's EN is tied to ITS
* OWN vdd node, i.e. the amplifier is enabled, which is the only state this
* bench characterizes. That is also the physically honest wiring -- a real
* enable is driven by CMOS logic on the same supply -- and it matters here
* because EN is not a quiet node: it gates a local inverter whose output
* holds the bias header's gate. Tying EN to a clean, separate source would
* hide any supply coupling that path contributes.
*
* ---------------------------------------------------------------------------
* Instances
* ---------------------------------------------------------------------------
*   X1  servo'd, OUT = 2.0 V           the ~50 mA regulation point at Vin=3.3 V
*                                      -> A0, UGBW, PM, gain @ 1 kHz, Vos, Iq,
*                                         and the TAIL headroom node
*   X2  servo'd, OUT = vdd_val - 0.4   the light-load point, where the PMOS
*                                      second stage is closest to triode
*                                      -> A0 and gain @ 1 kHz there
*   X3  VDD = 2.10 V (the dropout test point of README note 4), servo'd to
*       OUT = 1.0 V                    -> proves the NMOS input pair still has
*                                         full gain with only 2.10 V of supply,
*                                         which is the whole reason the pair is
*                                         NMOS and not PMOS (design/error_amp.md)
*   X4  VDD = 2.10 V, INP 250 mV BELOW INN
*                                      -> how close to VSS the gate is driven,
*                                         i.e. is the pass device on hard at the
*                                         dropout test point
*   X5  INP 250 mV ABOVE INN           -> how close to VDD the gate is driven,
*                                         i.e. can the pass device be turned off
*
* Every instance carries a lumped 6.14 pF output load: the measured worst-case
* Cgg of the pfet_03v3 pass device at W = 4 mm / L = 0.28 um, ss / -40 C
* (sim/devchar/CONCLUSIONS.md S1).

.param cgate=6.14p
.param vcm=1.2
.param vg_op=2.0
.param vdrop=2.10
.param vg_drop=1.0

* ==== X1: servo'd to OUT = vg_op, AC-driven on INP ==========================
Vsup1 vdd1  0 dc {vdd_val}
Vfb   nfb   0 dc {vcm} ac 1
Lfb1  vg1   nls1 1T
Vls1  nls1  nref1 dc {vg_op-vcm}
Cref1 nref1 0 1
Cl1   vg1   0 {cgate}
X1 nfb nref1 vg1 vdd1 0 vdd1 bg1 error_amp

* ==== X2: servo'd to OUT = vdd_val - 0.4 (light-load operating point) =======
Vsup2 vdd2  0 dc {vdd_val}
Lfb2  vg2   nls2 1T
Vls2  nls2  nref2 dc {vdd_val-0.4-vcm}
Cref2 nref2 0 1
Cl2   vg2   0 {cgate}
X2 nfb nref2 vg2 vdd2 0 vdd2 bg2 error_amp

* ==== X3: dropout test point (VDD = 2.10 V), servo'd to OUT = vg_drop =======
Vsup3 vdd3  0 dc {vdrop}
Lfb3  vg3   nls3 1T
Vls3  nls3  nref3 dc {vg_drop-vcm}
Cref3 nref3 0 1
Cl3   vg3   0 {cgate}
X3 nfb nref3 vg3 vdd3 0 vdd3 bg3 error_amp

* ==== X4: dropout test point, driven to pull the pass gate DOWN ============
Vsup4 vdd4  0 dc {vdrop}
Vref4 nref4 0 dc {vcm}
Vfb4  nfb4  0 dc {vcm-0.25}
Cl4   vg4   0 {cgate}
X4 nfb4 nref4 vg4 vdd4 0 vdd4 bg4 error_amp

* ==== X5: driven to pull the pass gate UP (pass device off) ================
Vsup5 vdd5  0 dc {vdd_val}
Vref5 nref5 0 dc {vcm}
Vfb5  nfb5  0 dc {vcm+0.25}
Cl5   vg5   0 {cgate}
X5 nfb5 nref5 vg5 vdd5 0 vdd5 bg5 error_amp
