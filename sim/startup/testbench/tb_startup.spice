* startup -- stimulus fragment for ldo_core (issue #12)
*
* Startup (README.md Target specification, "Startup" row; DR-0004
* amendment A9): monotonic into any load 0-50mA, controlled ramp <=1V/ms,
* inside +/-2% within 3ms of enable, overshoot <=+2%.
*
* Three independent ldo_core instances share one Vsup and one EN pulse but
* have separate resistive loads, so full-load, min-load and
* into-current-limit startup are all captured in a SINGLE tran run:
*   - _full  : Rload=36 Ohm  (~50 mA at 1.8V -- full-load startup)
*   - _min   : Rload=1.8 MOhm (~1 uA -- effectively the divider-only
*              minimum-load startup; the ratified "0 mA external load"
*              condition, using a large-but-finite R so the op point is
*              well-posed at t=0 before EN asserts)
*   - _short : Rload=1 Ohm (near dead short -- "startup into current
*              limit"). The DUT now instantiates Xilimit (issue #11 / PR
*              #39, closed) and Xsoftstart (issue #38 / PR #44), so this
*              branch is evidence of inrush into a PROTECTED near-short
*              (not the unprotected inrush the pre-#39 record measured),
*              still against no ratified short-circuit-current row -- see
*              tb.json's Claim for the honest framing and carries no
*              pass/fail checks either way.
* Resistive loads (not ideal current sinks) are used throughout because an
* ideal current sink into Vout=0V at t=0 (EN still low) is non-physical and
* drives the node to an unbounded negative rail before EN ever asserts --
* confirmed by hand during implementation.
*
* INTEGRATION METHOD (issue #48)
*
* Once the DUT gained Xilimit and Xsoftstart, this deck stopped being
* runnable: ngspice's default trapezoidal integrator rang on the _short
* branch (a cold enable into a near dead short immediately drives
* Xilimit's current limiter into its clamped regime, which is a fast,
* near-discontinuous switching event) and collapsed its timestep for the
* rest of the 6 ms window -- ngspice integrates one deck on one global
* timestep, so the other two branches paid for it too. Measured at
* tt/27C/3.30V, CPU seconds to simulate the full 6 ms window:
*
*   default (trapezoidal) integration      >120 s CPU and still not done
*                                           (matches this issue's own
*                                           finding of ~2 min CPU to reach
*                                           only 1.49 ms of 6 ms, i.e. an
*                                           extrapolated ~8 min/corner)
*   .options method=gear                   11.7 s CPU, completes cleanly
*
* Gear (backward-differentiation) integration is the standard SPICE fix
* for exactly this failure mode: it does not ring the way trapezoidal
* does across a fast switching event, so it does not need to shrink its
* timestep to control it. Switching to it is an integration-METHOD choice,
* not a tolerance relaxation -- reltol/abstol/vntol/chgtol are all left at
* the ngspice defaults -- but it changes which numerical algorithm produces
* the recorded values, so it is disclosed here and in tb.json's Claim per
* the sim/soft-start/ precedent for disclosing integrator changes. Sanity
* check against the (still trapezoidal, unaffected) _full/_min branches
* run standalone: tsettle_full_ms 3.79087 vs 3.79087, overshoot_full_mv
* -27.688 vs -27.358 mV, tsettle_min_ms 3.88350 vs 3.88377,
* overshoot_min_mv -13.663 vs -13.661 mV (gear vs default trapezoidal) --
* sub-1.2%-of-scale agreement, well inside corner-to-corner spread.
.options method=gear
Vsup VIN 0 DC {vdd_val}
Ven EN 0 PULSE(0 {vdd_val} 1u 1n 1n 10m 20m)

* --- Reference (issue #174 / DR-0021) ------------------------------------
* VREF is a TOP-LEVEL PORT of ldo_core as of #174; it used to be an internal
* net driven by Vref1, an ideal 1.2 V vsource instantiated INSIDE the
* subcircuit. That source is deleted from design/ldo_core.sch and reappears
* here, unchanged, at deck level. This is an electrical no-op by
* construction: an ideal vsource is an ideal vsource wherever it is
* declared, its return was already the cell's VSS port (node 0 here), and it
* is an AC short to ground in both placements -- so DC operating points, .ac
* transfers and transients are all identical to the pre-#174 deck. The point
* of the move is that the idealization is now visible at the interface and a
* real reference (a bandgap block, or the Chipalooza Challenge #5 harness's
* bandgap-referenced bias-voltage slot) can drive it without editing the
* schematic. One source serves every DUT instance in this deck: an ideal
* source has zero output impedance, so instances cannot interact through it.
Vref VREF 0 DC 1.2

Xdut_full VIN VOUT_FULL EN 0 LOOP_FULL LOOP_FULL VREF ldo_core
Rload_full VOUT_FULL 0 36
Resr_full VOUT_FULL n_esr_full 0.1
Cout_full n_esr_full 0 4.7u

Xdut_min VIN VOUT_MIN EN 0 LOOP_MIN LOOP_MIN VREF ldo_core
Rload_min VOUT_MIN 0 1.8Meg
Resr_min VOUT_MIN n_esr_min 0.1
Cout_min n_esr_min 0 4.7u

Vamm_short VIN VIN_SHORT 0
Xdut_short VIN_SHORT VOUT_SHORT EN 0 LOOP_SHORT LOOP_SHORT VREF ldo_core
Rload_short VOUT_SHORT 0 1
Resr_short VOUT_SHORT n_esr_short 0.1
Cout_short n_esr_short 0 4.7u
