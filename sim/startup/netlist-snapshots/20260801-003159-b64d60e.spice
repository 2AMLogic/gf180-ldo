* Frozen netlist snapshot for record 20260801-003159-b64d60e
* source     : design/netlist/ldo_core.spice
* sha256     : 78dbaa8f3c830902fe1abd744edbe764d3b33c7fdb30a7b150f4f1643a71377c
* This is a verbatim copy taken at record time. Do not edit.
* ldo_core -- generated by design/netlist.py from design/ldo_core.sch
* Do not edit: edit the schematic and re-run the export.
** sch_path: design/ldo_core.sch
.subckt ldo_core VIN VOUT EN VSS ERRAMP_OUT PASS_GATE
*.PININFO VIN:B VOUT:B EN:I VSS:B ERRAMP_OUT:O PASS_GATE:I
XMpass VOUT PASS_GATE VIN VIN pfet_03v3 L=0.28u W=2000u nf=40 ad='int((nf+1)/2) * W/nf * 0.18u' as='int((nf+2)/2) * W/nf * 0.18u' pd='2*int((nf+1)/2) * (W/nf + 0.18u)'
+ ps='2*int((nf+2)/2) * (W/nf + 0.18u)' nrd='0.18u / W' nrs='0.18u / W' sa=0 sb=0 sd=0 m=1
XMen PASS_GATE EN VIN VIN pfet_03v3 L=0.28u W=50u nf=2 ad='int((nf+1)/2) * W/nf * 0.18u' as='int((nf+2)/2) * W/nf * 0.18u' pd='2*int((nf+1)/2) * (W/nf + 0.18u)'
+ ps='2*int((nf+2)/2) * (W/nf + 0.18u)' nrd='0.18u / W' nrs='0.18u / W' sa=0 sb=0 sd=0 m=1
Rtop VOUT FB 200k m=1
Rbot FB VSS 100k m=1
Vref1 VREF VSS 0.6
Xerramp FB VREF ERRAMP_OUT VIN VSS ldo_erramp_placeholder
.ends

* expanding   symbol:  ldo_erramp_placeholder.sym # of pins=5
** sym_path: design/ldo_erramp_placeholder.sym
** sch_path: design/ldo_erramp_placeholder.sch
.subckt ldo_erramp_placeholder INP INN OUT VDD VSS
*.PININFO INP:I INN:I OUT:O VDD:B VSS:B
Bamp ERR_INT VSS V = 'min(V(vdd),max(V(vss),3162*(V(inp)-V(inn))))' m=1
Rout ERR_INT OUT 1Meg m=1
Rplaceholder_vdd VDD VSS 1T m=1
.ends
