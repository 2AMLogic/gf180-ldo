* amp-selfosc -- does the error amplifier's INTERNAL loop oscillate?
*
* Stimulus fragment for ldo_core (issue #53). The harness supplies the title,
* the gf180mcu model .include, the corner .lib sections, .temp, the .control
* block and .end, plus the DUT .include named by tb.json's "dut_netlist".
* Harness-supplied parameters: vdd_val, vdd_nom, temp_c.
*
* ---------------------------------------------------------------------------
* Why this experiment exists
* ---------------------------------------------------------------------------
* sim/loop-stability/ measures the LDO loop's Bode phase and gain margins.
* Those two numbers are a valid stability test ONLY when the loop gain T(s)
* has no right-half-plane poles -- i.e. when the forward path is itself
* stable with the loop broken. That precondition is not checked anywhere,
* and it is not free: design/error_amp.sch closes a LOCAL feedback loop
* inside the amplifier (the Rz/Cc Miller network from N1 around the stage-2
* driver M2P and the class-AB gate buffer back to OUT) which stays closed
* when the LDO loop is broken at ERRAMP_OUT/PASS_GATE. If that local loop is
* unstable, T(s) has RHP poles, the Bode criterion does not apply, and
* `180 + phase` at the 0 dB crossing reports a large positive number that
* sails past a ">= 45 deg" check while the amplifier is ringing.
*
* This bench answers the question the frequency-domain benches cannot: with
* the regulator settled and nothing driving it inside the measurement
* window, is there residual periodic activity on the amplifier's own nodes?
* A stable loop settles to its DC operating point and stays there, so the
* peak-to-peak of an internal node over a late, quiet window is a direct,
* waveform-level, pass/fail answer that no phase-unwrapping convention can
* launder.
*
* ---------------------------------------------------------------------------
* How it is set up
* ---------------------------------------------------------------------------
* Two ldo_core instances, both with the loop tied closed (ERRAMP_OUT and
* PASS_GATE on one node, the normal-operation wiring design/README.md
* describes), share one supply and one enable:
*
*   _light  18 kOhm  -> ~0.1 mA, the lightest load DR-0001's stability
*                      envelope still claims, and the load column issue #53
*                      is about
*   _heavy  36 Ohm   -> ~50 mA, the full rated load, so a positive result
*                      cannot be dismissed as a light-load-only artifact
*
* Both carry C_eff = 0.33 uF with 1 mOhm ESR: the a-priori worst point of
* DR-0001's window (smallest capacitance, no ESR zero).
*
* EN is held at VIN for the whole run rather than stepped, so the operating
* point the transient starts from IS the settled regulating solution and the
* measured window contains no enable transient to confuse with oscillation.
* The only excitation is the Ikick_* seed described further down, which is
* over 190 us before the window opens.
*
* Resistive loads, not ideal current sinks -- the same reason
* sim/startup/testbench and sim/current-limit/testbench give: an ideal sink
* makes the t=0 operating point ill-posed.
*
* ---------------------------------------------------------------------------
* Integration method
* ---------------------------------------------------------------------------
* .options method=gear, for the same reason sim/startup/ uses it (issue #48)
* and for one more that matters here specifically: Gear/BDF integration is
* NUMERICALLY DAMPING, while ngspice's default trapezoidal rule is not and
* can sustain a ringing artifact of its own. Measuring an oscillation under
* the damping integrator is the conservative choice -- a positive result
* here cannot be an artifact of the integrator, because the integrator is
* biased against it. reltol/abstol/vntol/chgtol stay at ngspice defaults.
*
* The 200 ns maximum timestep is ~10 points per period of the ~500 kHz
* activity this bench was written to catch. It is load-bearing, not a
* performance knob: Gear integration is damping, so a coarser ceiling damps
* the signal being measured (verified at tt/27C/3.30V -- a 400 ns ceiling
* reports 37 nV pk-pk on the heavy branch where 200 ns reports 3.31 V).
*
* ---------------------------------------------------------------------------
* Why there IS a stimulus, and why it is outside the measurement window
* ---------------------------------------------------------------------------
* An unstable loop started only by the integrator's own truncation noise
* grows from whatever that noise happens to be, so how far it has grown by a
* given time is not reproducible run to run -- measured, the light branch
* reads 1.21 V pk-pk in one window and sub-microvolt in another on the SAME
* netlist, purely because the two runs' timestep sequences seed it
* differently. A negative would then be unfalsifiable.
*
* Ikick_* fixes that: a 1 nA, 1 us current pulse into each pass gate at
* t = 10 us, i.e. 190 us (about 95 periods) before the measurement window
* opens. It is far too small to be a stimulus in any meaningful sense -- the
* pass gate node sits at a ~20 kOhm buffer output, so 1 nA is ~20 uV of
* excitation -- but it is a DEFINED seed, identical at every corner, so the
* measured peak-to-peak is a statement about the loop's response to a
* perturbation rather than about the integrator's noise. A stable loop
* returns to its operating point long before the window opens; an unstable
* one has grown to its limit cycle. Both branches are seeded identically so
* the light and heavy readings are comparable.

.options method=gear
Vsup VIN 0 DC {vdd_val}
Ven  EN  0 DC {vdd_val}

Xdut_light VIN VOUT_LIGHT EN 0 LOOP_LIGHT LOOP_LIGHT ldo_core
Rload_light VOUT_LIGHT 0 18k
Resr_light  VOUT_LIGHT n_esr_light 0.001
Cout_light  n_esr_light 0 0.33u

Xdut_heavy VIN VOUT_HEAVY EN 0 LOOP_HEAVY LOOP_HEAVY ldo_core
Rload_heavy VOUT_HEAVY 0 36
Resr_heavy  VOUT_HEAVY n_esr_heavy 0.001
Cout_heavy  n_esr_heavy 0 0.33u

* Deterministic seed -- see the header. 1 nA for 1 us at t = 10 us, which is
* 190 us before the measurement window opens.
Ikick_light 0 LOOP_LIGHT PULSE(0 1n 10u 1n 1n 1u 1)
Ikick_heavy 0 LOOP_HEAVY PULSE(0 1n 10u 1n 1n 1u 1)
