* Frozen netlist snapshot for record 20260802-164210-7c2ff06
* This is a verbatim copy taken at record time. Do not edit.

* ======================================================================
* DUT netlist          : design/netlist/ldo_core.spice
* sha256               : da744648b3c69c589f7f956f1e8159da8e0b17bf20d1d8e24f5c331a87f96361
* ======================================================================
* ldo_core -- generated by design/netlist.py from design/ldo_core.sch
* Do not edit: edit the schematic and re-run the export.
** sch_path: design/ldo_core.sch
.subckt ldo_core VIN VOUT EN VSS ERRAMP_OUT PASS_GATE
*.PININFO VIN:B VOUT:B EN:I VSS:B ERRAMP_OUT:O PASS_GATE:I
XMpass VOUT PASS_GATE VIN VIN pfet_03v3 L=0.28u W=2000u nf=40 ad='int((nf+1)/2) * W/nf * 0.18u' as='int((nf+2)/2) * W/nf * 0.18u' pd='2*int((nf+1)/2) * (W/nf + 0.18u)'
+ ps='2*int((nf+2)/2) * (W/nf + 0.18u)' nrd='0.18u / W' nrs='0.18u / W' sa=0 sb=0 sd=0 m=1
XMen PASS_GATE EN VIN VIN pfet_03v3 L=0.28u W=50u nf=2 ad='int((nf+1)/2) * W/nf * 0.18u' as='int((nf+2)/2) * W/nf * 0.18u' pd='2*int((nf+1)/2) * (W/nf + 0.18u)'
+ ps='2*int((nf+2)/2) * (W/nf + 0.18u)' nrd='0.18u / W' nrs='0.18u / W' sa=0 sb=0 sd=0 m=1
Rtop VOUT FB 300k m=1
XCff VOUT FB cap_mim_2f0_m2m3_noshield c_width=87u c_length=87u m=1
Rbot FB VSS 600k m=1
Vref1 VREF VSS 1.2
Xerramp FB VREF ERRAMP_OUT VIN VSS EN BG error_amp
Xilimit VIN VOUT PASS_GATE EN VREF VSS BG ldo_ilimit
Xsoftstart VIN FB PASS_GATE EN VREF VSS BG ldo_softstart
.ends

* expanding   symbol:  error_amp.sym # of pins=7
** sym_path: design/error_amp.sym
** sch_path: design/error_amp.sch
.subckt error_amp INP INN OUT VDD VSS EN BG
*.PININFO INP:I INN:I OUT:O VDD:B VSS:B EN:I BG:B
XRbias NBIAS RBT VSS ppolyf_u_1k r_width=1u r_length=1000u m=1
XMB1 NBIAS NBIAS VSS VSS nfet_03v3 L=4u W=6u nf=1 ad='int((nf+1)/2) * W/nf * 0.18u' as='int((nf+2)/2) * W/nf * 0.18u' pd='2*int((nf+1)/2) * (W/nf + 0.18u)'
+ ps='2*int((nf+2)/2) * (W/nf + 0.18u)' nrd='0.18u / W' nrs='0.18u / W' sa=0 sb=0 sd=0 m=1
XMTAIL TAIL NBIAS VSS VSS nfet_03v3 L=4u W=6.6u nf=1 ad='int((nf+1)/2) * W/nf * 0.18u' as='int((nf+2)/2) * W/nf * 0.18u' pd='2*int((nf+1)/2) * (W/nf + 0.18u)'
+ ps='2*int((nf+2)/2) * (W/nf + 0.18u)' nrd='0.18u / W' nrs='0.18u / W' sa=0 sb=0 sd=0 m=1
XMIN1 ND INN TAIL VSS nfet_03v3 L=6u W=60u nf=6 ad='int((nf+1)/2) * W/nf * 0.18u' as='int((nf+2)/2) * W/nf * 0.18u' pd='2*int((nf+1)/2) * (W/nf + 0.18u)'
+ ps='2*int((nf+2)/2) * (W/nf + 0.18u)' nrd='0.18u / W' nrs='0.18u / W' sa=0 sb=0 sd=0 m=1
XMIN2 N1 INP TAIL VSS nfet_03v3 L=6u W=60u nf=6 ad='int((nf+1)/2) * W/nf * 0.18u' as='int((nf+2)/2) * W/nf * 0.18u' pd='2*int((nf+1)/2) * (W/nf + 0.18u)'
+ ps='2*int((nf+2)/2) * (W/nf + 0.18u)' nrd='0.18u / W' nrs='0.18u / W' sa=0 sb=0 sd=0 m=1
XMLD1 ND ND VDD VDD pfet_03v3 L=8u W=8u nf=1 ad='int((nf+1)/2) * W/nf * 0.18u' as='int((nf+2)/2) * W/nf * 0.18u' pd='2*int((nf+1)/2) * (W/nf + 0.18u)'
+ ps='2*int((nf+2)/2) * (W/nf + 0.18u)' nrd='0.18u / W' nrs='0.18u / W' sa=0 sb=0 sd=0 m=1
XMLD2 N1 ND VDD VDD pfet_03v3 L=8u W=8u nf=1 ad='int((nf+1)/2) * W/nf * 0.18u' as='int((nf+2)/2) * W/nf * 0.18u' pd='2*int((nf+1)/2) * (W/nf + 0.18u)'
+ ps='2*int((nf+2)/2) * (W/nf + 0.18u)' nrd='0.18u / W' nrs='0.18u / W' sa=0 sb=0 sd=0 m=1
XRz NZ N1 VSS ppolyf_u_1k r_width=1u r_length=6000u m=1
XCc NZ OUT cap_mim_2f0_m2m3_noshield c_width=48u c_length=48u m=1
XCf1 N1 NF cap_mim_2f0_m2m3_noshield c_width=7u c_length=7u m=1
XCf2 NF BG cap_mim_2f0_m2m3_noshield c_width=7u c_length=7u m=1
XM2P BG N1 VDD VDD pfet_03v3 L=1u W=60u nf=6 ad='int((nf+1)/2) * W/nf * 0.18u' as='int((nf+2)/2) * W/nf * 0.18u' pd='2*int((nf+1)/2) * (W/nf + 0.18u)'
+ ps='2*int((nf+2)/2) * (W/nf + 0.18u)' nrd='0.18u / W' nrs='0.18u / W' sa=0 sb=0 sd=0 m=1
XM2N BG NBIAS VSS VSS nfet_03v3 L=4u W=4u nf=1 ad='int((nf+1)/2) * W/nf * 0.18u' as='int((nf+2)/2) * W/nf * 0.18u' pd='2*int((nf+1)/2) * (W/nf + 0.18u)'
+ ps='2*int((nf+2)/2) * (W/nf + 0.18u)' nrd='0.18u / W' nrs='0.18u / W' sa=0 sb=0 sd=0 m=1
XRbufb NBP N1 VSS ppolyf_u_1k r_width=1u r_length=5000u m=1
XMbufb OUT NBP VDD VDD pfet_03v3 L=1u W=100u nf=10 ad='int((nf+1)/2) * W/nf * 0.18u' as='int((nf+2)/2) * W/nf * 0.18u' pd='2*int((nf+1)/2) * (W/nf + 0.18u)'
+ ps='2*int((nf+2)/2) * (W/nf + 0.18u)' nrd='0.18u / W' nrs='0.18u / W' sa=0 sb=0 sd=0 m=1
XMbuf OUT BG VSS OUT pfet_03v3 L=0.5u W=60u nf=6 ad='int((nf+1)/2) * W/nf * 0.18u' as='int((nf+2)/2) * W/nf * 0.18u' pd='2*int((nf+1)/2) * (W/nf + 0.18u)'
+ ps='2*int((nf+2)/2) * (W/nf + 0.18u)' nrd='0.18u / W' nrs='0.18u / W' sa=0 sb=0 sd=0 m=1
XMpgn OUT NBIAS VSS VSS nfet_03v3 L=8u W=2u nf=1 ad='int((nf+1)/2) * W/nf * 0.18u' as='int((nf+2)/2) * W/nf * 0.18u' pd='2*int((nf+1)/2) * (W/nf + 0.18u)'
+ ps='2*int((nf+2)/2) * (W/nf + 0.18u)' nrd='0.18u / W' nrs='0.18u / W' sa=0 sb=0 sd=0 m=1
XMbg_pu BG EN VDD VDD pfet_03v3 L=0.5u W=4u nf=1 ad='int((nf+1)/2) * W/nf * 0.18u' as='int((nf+2)/2) * W/nf * 0.18u' pd='2*int((nf+1)/2) * (W/nf + 0.18u)'
+ ps='2*int((nf+2)/2) * (W/nf + 0.18u)' nrd='0.18u / W' nrs='0.18u / W' sa=0 sb=0 sd=0 m=1
XMinv_p ENB EN VDD VDD pfet_03v3 L=0.5u W=4u nf=1 ad='int((nf+1)/2) * W/nf * 0.18u' as='int((nf+2)/2) * W/nf * 0.18u' pd='2*int((nf+1)/2) * (W/nf + 0.18u)'
+ ps='2*int((nf+2)/2) * (W/nf + 0.18u)' nrd='0.18u / W' nrs='0.18u / W' sa=0 sb=0 sd=0 m=1
XMinv_n ENB EN VSS VSS nfet_03v3 L=0.5u W=2u nf=1 ad='int((nf+1)/2) * W/nf * 0.18u' as='int((nf+2)/2) * W/nf * 0.18u' pd='2*int((nf+1)/2) * (W/nf + 0.18u)'
+ ps='2*int((nf+2)/2) * (W/nf + 0.18u)' nrd='0.18u / W' nrs='0.18u / W' sa=0 sb=0 sd=0 m=1
XMbias_h RBT ENB VDD VDD pfet_03v3 L=0.5u W=20u nf=1 ad='int((nf+1)/2) * W/nf * 0.18u' as='int((nf+2)/2) * W/nf * 0.18u' pd='2*int((nf+1)/2) * (W/nf + 0.18u)'
+ ps='2*int((nf+2)/2) * (W/nf + 0.18u)' nrd='0.18u / W' nrs='0.18u / W' sa=0 sb=0 sd=0 m=1
XMnb_pd NBIAS ENB VSS VSS nfet_03v3 L=0.5u W=10u nf=1 ad='int((nf+1)/2) * W/nf * 0.18u' as='int((nf+2)/2) * W/nf * 0.18u' pd='2*int((nf+1)/2) * (W/nf + 0.18u)'
+ ps='2*int((nf+2)/2) * (W/nf + 0.18u)' nrd='0.18u / W' nrs='0.18u / W' sa=0 sb=0 sd=0 m=1
XMn1_pu N1 EN VDD VDD pfet_03v3 L=0.5u W=4u nf=1 ad='int((nf+1)/2) * W/nf * 0.18u' as='int((nf+2)/2) * W/nf * 0.18u' pd='2*int((nf+1)/2) * (W/nf + 0.18u)'
+ ps='2*int((nf+2)/2) * (W/nf + 0.18u)' nrd='0.18u / W' nrs='0.18u / W' sa=0 sb=0 sd=0 m=1
XMnd_pu ND EN VDD VDD pfet_03v3 L=0.5u W=4u nf=1 ad='int((nf+1)/2) * W/nf * 0.18u' as='int((nf+2)/2) * W/nf * 0.18u' pd='2*int((nf+1)/2) * (W/nf + 0.18u)'
+ ps='2*int((nf+2)/2) * (W/nf + 0.18u)' nrd='0.18u / W' nrs='0.18u / W' sa=0 sb=0 sd=0 m=1
.ends

* expanding   symbol:  ldo_ilimit.sym # of pins=7
** sym_path: design/ldo_ilimit.sym
** sch_path: design/ldo_ilimit.sch
.subckt ldo_ilimit VIN VOUT PASS_GATE EN VREF VSS BG
*.PININFO VIN:B VOUT:B PASS_GATE:B EN:I VREF:I VSS:B BG:B
XMsense ISNS PASS_GATE VIN VIN pfet_03v3 L=0.28u W=50u nf=1 ad='int((nf+1)/2) * W/nf * 0.18u' as='int((nf+2)/2) * W/nf * 0.18u' pd='2*int((nf+1)/2) * (W/nf + 0.18u)'
+ ps='2*int((nf+2)/2) * (W/nf + 0.18u)' nrd='0.18u / W' nrs='0.18u / W' sa=0 sb=0 sd=0 m=1
XRsns VOUT ISNS VSS ppolyf_u r_width=5u r_length=7.6u m=10
XMpd PB PB VIN VIN pfet_03v3 L=2u W=10u nf=1 ad='int((nf+1)/2) * W/nf * 0.18u' as='int((nf+2)/2) * W/nf * 0.18u' pd='2*int((nf+1)/2) * (W/nf + 0.18u)'
+ ps='2*int((nf+2)/2) * (W/nf + 0.18u)' nrd='0.18u / W' nrs='0.18u / W' sa=0 sb=0 sd=0 m=1
XMrefp VTH PB VIN VIN pfet_03v3 L=2u W=10u nf=1 ad='int((nf+1)/2) * W/nf * 0.18u' as='int((nf+2)/2) * W/nf * 0.18u' pd='2*int((nf+1)/2) * (W/nf + 0.18u)'
+ ps='2*int((nf+2)/2) * (W/nf + 0.18u)' nrd='0.18u / W' nrs='0.18u / W' sa=0 sb=0 sd=0 m=1
XRref VOUT VTH VSS ppolyf_u_3k r_width=1u r_length=30u m=1
Fbias PB VSS Vbsense 1
Vbsense VREF BT 0
XRbias BB BT VSS ppolyf_u_3k r_width=1u r_length=360u m=1
XMben BB EN VSS VSS nfet_03v3 L=0.5u W=20u nf=1 ad='int((nf+1)/2) * W/nf * 0.18u' as='int((nf+2)/2) * W/nf * 0.18u' pd='2*int((nf+1)/2) * (W/nf + 0.18u)'
+ ps='2*int((nf+2)/2) * (W/nf + 0.18u)' nrd='0.18u / W' nrs='0.18u / W' sa=0 sb=0 sd=0 m=1
XMca CN ISNS TAIL VIN pfet_03v3 L=1u W=20u nf=1 ad='int((nf+1)/2) * W/nf * 0.18u' as='int((nf+2)/2) * W/nf * 0.18u' pd='2*int((nf+1)/2) * (W/nf + 0.18u)'
+ ps='2*int((nf+2)/2) * (W/nf + 0.18u)' nrd='0.18u / W' nrs='0.18u / W' sa=0 sb=0 sd=0 m=1
XMcb CO VTH TAIL VIN pfet_03v3 L=1u W=20u nf=1 ad='int((nf+1)/2) * W/nf * 0.18u' as='int((nf+2)/2) * W/nf * 0.18u' pd='2*int((nf+1)/2) * (W/nf + 0.18u)'
+ ps='2*int((nf+2)/2) * (W/nf + 0.18u)' nrd='0.18u / W' nrs='0.18u / W' sa=0 sb=0 sd=0 m=1
XRtail TAIL TAILP VSS ppolyf_u_3k r_width=1u r_length=150u m=1
XMna CN CN VSS VSS nfet_03v3 L=1u W=20u nf=1 ad='int((nf+1)/2) * W/nf * 0.18u' as='int((nf+2)/2) * W/nf * 0.18u' pd='2*int((nf+1)/2) * (W/nf + 0.18u)'
+ ps='2*int((nf+2)/2) * (W/nf + 0.18u)' nrd='0.18u / W' nrs='0.18u / W' sa=0 sb=0 sd=0 m=1
XMnb CO CN VSS VSS nfet_03v3 L=1u W=20u nf=1 ad='int((nf+1)/2) * W/nf * 0.18u' as='int((nf+2)/2) * W/nf * 0.18u' pd='2*int((nf+1)/2) * (W/nf + 0.18u)'
+ ps='2*int((nf+2)/2) * (W/nf + 0.18u)' nrd='0.18u / W' nrs='0.18u / W' sa=0 sb=0 sd=0 m=1
XMen_co CO ENB VSS VSS nfet_03v3 L=0.5u W=20u nf=1 ad='int((nf+1)/2) * W/nf * 0.18u' as='int((nf+2)/2) * W/nf * 0.18u' pd='2*int((nf+1)/2) * (W/nf + 0.18u)'
+ ps='2*int((nf+2)/2) * (W/nf + 0.18u)' nrd='0.18u / W' nrs='0.18u / W' sa=0 sb=0 sd=0 m=1
XCc CO VSS cap_mim_2f0_m2m3_noshield c_width=25u c_length=20u m=1
XMg2 CLG CO VSS VSS nfet_03v3 L=1u W=10u nf=1 ad='int((nf+1)/2) * W/nf * 0.18u' as='int((nf+2)/2) * W/nf * 0.18u' pd='2*int((nf+1)/2) * (W/nf + 0.18u)'
+ ps='2*int((nf+2)/2) * (W/nf + 0.18u)' nrd='0.18u / W' nrs='0.18u / W' sa=0 sb=0 sd=0 m=1
XRl2 CLG VIN VSS ppolyf_u_3k r_width=1u r_length=150u m=1
XMcoff CLG EN VIN VIN pfet_03v3 L=0.5u W=10u nf=1 ad='int((nf+1)/2) * W/nf * 0.18u' as='int((nf+2)/2) * W/nf * 0.18u' pd='2*int((nf+1)/2) * (W/nf + 0.18u)'
+ ps='2*int((nf+2)/2) * (W/nf + 0.18u)' nrd='0.18u / W' nrs='0.18u / W' sa=0 sb=0 sd=0 m=1
XMclamp PASS_GATE CLG VIN VIN pfet_03v3 L=0.5u W=50u nf=1 ad='int((nf+1)/2) * W/nf * 0.18u' as='int((nf+2)/2) * W/nf * 0.18u' pd='2*int((nf+1)/2) * (W/nf + 0.18u)'
+ ps='2*int((nf+2)/2) * (W/nf + 0.18u)' nrd='0.18u / W' nrs='0.18u / W' sa=0 sb=0 sd=0 m=1
XMclamp_bg BG CLG VIN VIN pfet_03v3 L=0.5u W=10u nf=1 ad='int((nf+1)/2) * W/nf * 0.18u' as='int((nf+2)/2) * W/nf * 0.18u' pd='2*int((nf+1)/2) * (W/nf + 0.18u)'
+ ps='2*int((nf+2)/2) * (W/nf + 0.18u)' nrd='0.18u / W' nrs='0.18u / W' sa=0 sb=0 sd=0 m=1
XMinv_p ENB EN VIN VIN pfet_03v3 L=0.5u W=4u nf=1 ad='int((nf+1)/2) * W/nf * 0.18u' as='int((nf+2)/2) * W/nf * 0.18u' pd='2*int((nf+1)/2) * (W/nf + 0.18u)'
+ ps='2*int((nf+2)/2) * (W/nf + 0.18u)' nrd='0.18u / W' nrs='0.18u / W' sa=0 sb=0 sd=0 m=1
XMinv_n ENB EN VSS VSS nfet_03v3 L=0.5u W=2u nf=1 ad='int((nf+1)/2) * W/nf * 0.18u' as='int((nf+2)/2) * W/nf * 0.18u' pd='2*int((nf+1)/2) * (W/nf + 0.18u)'
+ ps='2*int((nf+2)/2) * (W/nf + 0.18u)' nrd='0.18u / W' nrs='0.18u / W' sa=0 sb=0 sd=0 m=1
XMen_t TAILP ENB VIN VIN pfet_03v3 L=0.5u W=10u nf=1 ad='int((nf+1)/2) * W/nf * 0.18u' as='int((nf+2)/2) * W/nf * 0.18u' pd='2*int((nf+1)/2) * (W/nf + 0.18u)'
+ ps='2*int((nf+2)/2) * (W/nf + 0.18u)' nrd='0.18u / W' nrs='0.18u / W' sa=0 sb=0 sd=0 m=1
.ends

* expanding   symbol:  ldo_softstart.sym # of pins=7
** sym_path: design/ldo_softstart.sym
** sch_path: design/ldo_softstart.sch
.subckt ldo_softstart VIN FB PASS_GATE EN VREF VSS BG
*.PININFO VIN:B FB:I PASS_GATE:B EN:I VREF:I VSS:B BG:B
Vbsense_ss VREF BT 0
XRss_bias BB BT VSS ppolyf_u_3k r_width=1u r_length=1000u m=1
XMben_ss BB EN VSS VSS nfet_03v3 L=0.5u W=20u nf=1 ad='int((nf+1)/2) * W/nf * 0.18u' as='int((nf+2)/2) * W/nf * 0.18u' pd='2*int((nf+1)/2) * (W/nf + 0.18u)'
+ ps='2*int((nf+2)/2) * (W/nf + 0.18u)' nrd='0.18u / W' nrs='0.18u / W' sa=0 sb=0 sd=0 m=1
Fss_ramp VIN SSR Vbsense_ss 0.0060
XCss SSR VSS cap_mim_2f0_m2m3_noshield c_width=60u c_length=60u m=1
XMdis_ss SSR ENB VSS VSS nfet_03v3 L=1u W=1u nf=1 ad='int((nf+1)/2) * W/nf * 0.18u' as='int((nf+2)/2) * W/nf * 0.18u' pd='2*int((nf+1)/2) * (W/nf + 0.18u)'
+ ps='2*int((nf+2)/2) * (W/nf + 0.18u)' nrd='0.18u / W' nrs='0.18u / W' sa=0 sb=0 sd=0 m=1
XMtop_ss VSS VREF SSR VIN pfet_03v3 L=2u W=1u nf=1 ad='int((nf+1)/2) * W/nf * 0.18u' as='int((nf+2)/2) * W/nf * 0.18u' pd='2*int((nf+1)/2) * (W/nf + 0.18u)'
+ ps='2*int((nf+2)/2) * (W/nf + 0.18u)' nrd='0.18u / W' nrs='0.18u / W' sa=0 sb=0 sd=0 m=1
XMen_t_ss TAILP ENB VIN VIN pfet_03v3 L=0.5u W=10u nf=1 ad='int((nf+1)/2) * W/nf * 0.18u' as='int((nf+2)/2) * W/nf * 0.18u' pd='2*int((nf+1)/2) * (W/nf + 0.18u)'
+ ps='2*int((nf+2)/2) * (W/nf + 0.18u)' nrd='0.18u / W' nrs='0.18u / W' sa=0 sb=0 sd=0 m=1
XRtail_ss TAIL TAILP VSS ppolyf_u_3k r_width=1u r_length=600u m=1
XMca_ss CN FB TAIL VIN pfet_03v3 L=1u W=20u nf=1 ad='int((nf+1)/2) * W/nf * 0.18u' as='int((nf+2)/2) * W/nf * 0.18u' pd='2*int((nf+1)/2) * (W/nf + 0.18u)'
+ ps='2*int((nf+2)/2) * (W/nf + 0.18u)' nrd='0.18u / W' nrs='0.18u / W' sa=0 sb=0 sd=0 m=1
XMcb_ss CO SSR TAIL VIN pfet_03v3 L=1u W=20u nf=1 ad='int((nf+1)/2) * W/nf * 0.18u' as='int((nf+2)/2) * W/nf * 0.18u' pd='2*int((nf+1)/2) * (W/nf + 0.18u)'
+ ps='2*int((nf+2)/2) * (W/nf + 0.18u)' nrd='0.18u / W' nrs='0.18u / W' sa=0 sb=0 sd=0 m=1
XMna_ss CN CN VSS VSS nfet_03v3 L=1u W=20u nf=1 ad='int((nf+1)/2) * W/nf * 0.18u' as='int((nf+2)/2) * W/nf * 0.18u' pd='2*int((nf+1)/2) * (W/nf + 0.18u)'
+ ps='2*int((nf+2)/2) * (W/nf + 0.18u)' nrd='0.18u / W' nrs='0.18u / W' sa=0 sb=0 sd=0 m=1
XMnb_ss CO CO VSS VSS nfet_03v3 L=1u W=20u nf=1 ad='int((nf+1)/2) * W/nf * 0.18u' as='int((nf+2)/2) * W/nf * 0.18u' pd='2*int((nf+1)/2) * (W/nf + 0.18u)'
+ ps='2*int((nf+2)/2) * (W/nf + 0.18u)' nrd='0.18u / W' nrs='0.18u / W' sa=0 sb=0 sd=0 m=1
XCc_ss CO VSS cap_mim_2f0_m2m3_noshield c_width=25u c_length=20u m=1
XMen_l LP ENB VIN VIN pfet_03v3 L=0.5u W=10u nf=1 ad='int((nf+1)/2) * W/nf * 0.18u' as='int((nf+2)/2) * W/nf * 0.18u' pd='2*int((nf+1)/2) * (W/nf + 0.18u)'
+ ps='2*int((nf+2)/2) * (W/nf + 0.18u)' nrd='0.18u / W' nrs='0.18u / W' sa=0 sb=0 sd=0 m=1
XRl2_ss CLG LP VSS ppolyf_u_3k r_width=1u r_length=2000u m=1
XMg2_ss CLG CO VSS VSS nfet_03v3 L=1u W=10u nf=1 ad='int((nf+1)/2) * W/nf * 0.18u' as='int((nf+2)/2) * W/nf * 0.18u' pd='2*int((nf+1)/2) * (W/nf + 0.18u)'
+ ps='2*int((nf+2)/2) * (W/nf + 0.18u)' nrd='0.18u / W' nrs='0.18u / W' sa=0 sb=0 sd=0 m=1
XMpark_ss CLG ENB VSS VSS nfet_03v3 L=0.5u W=10u nf=1 ad='int((nf+1)/2) * W/nf * 0.18u' as='int((nf+2)/2) * W/nf * 0.18u' pd='2*int((nf+1)/2) * (W/nf + 0.18u)'
+ ps='2*int((nf+2)/2) * (W/nf + 0.18u)' nrd='0.18u / W' nrs='0.18u / W' sa=0 sb=0 sd=0 m=1
XMclamp_ss PASS_GATE CLG VIN VIN pfet_03v3 L=0.5u W=20u nf=1 ad='int((nf+1)/2) * W/nf * 0.18u' as='int((nf+2)/2) * W/nf * 0.18u' pd='2*int((nf+1)/2) * (W/nf + 0.18u)'
+ ps='2*int((nf+2)/2) * (W/nf + 0.18u)' nrd='0.18u / W' nrs='0.18u / W' sa=0 sb=0 sd=0 m=1
XCm_ss CLG PASS_GATE cap_mim_2f0_m2m3_noshield c_width=60u c_length=60u m=1
XMinv_p ENB EN VIN VIN pfet_03v3 L=0.5u W=4u nf=1 ad='int((nf+1)/2) * W/nf * 0.18u' as='int((nf+2)/2) * W/nf * 0.18u' pd='2*int((nf+1)/2) * (W/nf + 0.18u)'
+ ps='2*int((nf+2)/2) * (W/nf + 0.18u)' nrd='0.18u / W' nrs='0.18u / W' sa=0 sb=0 sd=0 m=1
XMclamp_bg_ss BG CLG VIN VIN pfet_03v3 L=0.5u W=10u nf=1 ad='int((nf+1)/2) * W/nf * 0.18u' as='int((nf+2)/2) * W/nf * 0.18u' pd='2*int((nf+1)/2) * (W/nf + 0.18u)'
+ ps='2*int((nf+2)/2) * (W/nf + 0.18u)' nrd='0.18u / W' nrs='0.18u / W' sa=0 sb=0 sd=0 m=1
XMinv_n ENB EN VSS VSS nfet_03v3 L=0.5u W=2u nf=1 ad='int((nf+1)/2) * W/nf * 0.18u' as='int((nf+2)/2) * W/nf * 0.18u' pd='2*int((nf+1)/2) * (W/nf + 0.18u)'
+ ps='2*int((nf+2)/2) * (W/nf + 0.18u)' nrd='0.18u / W' nrs='0.18u / W' sa=0 sb=0 sd=0 m=1
.ends

* ======================================================================
* testbench fragment   : sim/amp-selfosc/testbench/tb_amp_selfosc.spice
* sha256               : f0c2260b8150f4a94fed0d37553c872cc39dab3a58247f721e1c7d328d29d711
* ======================================================================
* amp-selfosc -- does the error amplifier's INTERNAL loop oscillate?
*
* Stimulus fragment for ldo_core (issue #53). The harness supplies the title,
* the gf180mcu model .include, the corner .lib sections, .temp, the .control
* block and .end, plus the DUT .include named by tb.json's "dut_netlist".
* Harness-supplied parameters: vdd_val, vdd_nom, temp_c.
*
* ---------------------------------------------------------------------------
* Why this experiment exists
* ---------------------------------------------------------------------------
* sim/loop-stability/ measures the LDO loop's Bode phase and gain margins.
* Those two numbers are a valid stability test ONLY when the loop gain T(s)
* has no right-half-plane poles -- i.e. when the forward path is itself
* stable with the loop broken. That precondition is not checked anywhere,
* and it is not free: design/error_amp.sch closes a LOCAL feedback loop
* inside the amplifier (the Rz/Cc Miller network from N1 around the stage-2
* driver M2P and the class-AB gate buffer back to OUT) which stays closed
* when the LDO loop is broken at ERRAMP_OUT/PASS_GATE. If that local loop is
* unstable, T(s) has RHP poles, the Bode criterion does not apply, and
* `180 + phase` at the 0 dB crossing reports a large positive number that
* sails past a ">= 45 deg" check while the amplifier is ringing.
*
* This bench answers the question the frequency-domain benches cannot: with
* the regulator settled and nothing driving it inside the measurement
* window, is there residual periodic activity on the amplifier's own nodes?
* A stable loop settles to its DC operating point and stays there, so the
* peak-to-peak of an internal node over a late, quiet window is a direct,
* waveform-level, pass/fail answer that no phase-unwrapping convention can
* launder.
*
* ---------------------------------------------------------------------------
* How it is set up
* ---------------------------------------------------------------------------
* Two ldo_core instances, both with the loop tied closed (ERRAMP_OUT and
* PASS_GATE on one node, the normal-operation wiring design/README.md
* describes), share one supply and one enable:
*
*   _light  18 kOhm  -> ~0.1 mA, the lightest load DR-0001's stability
*                      envelope still claims, and the load column issue #53
*                      is about
*   _heavy  36 Ohm   -> ~50 mA, the full rated load, so a positive result
*                      cannot be dismissed as a light-load-only artifact
*
* Both carry C_eff = 0.33 uF with 1 mOhm ESR: the a-priori worst point of
* DR-0001's window (smallest capacitance, no ESR zero).
*
* EN is held at VIN for the whole run rather than stepped, so the operating
* point the transient starts from IS the settled regulating solution and the
* measured window contains no enable transient to confuse with oscillation.
* The only excitation is the Ikick_* seed described further down, which is
* over 190 us before the window opens.
*
* Resistive loads, not ideal current sinks -- the same reason
* sim/startup/testbench and sim/current-limit/testbench give: an ideal sink
* makes the t=0 operating point ill-posed.
*
* ---------------------------------------------------------------------------
* Integration method
* ---------------------------------------------------------------------------
* .options method=gear, for the same reason sim/startup/ uses it (issue #48)
* and for one more that matters here specifically: Gear/BDF integration is
* NUMERICALLY DAMPING, while ngspice's default trapezoidal rule is not and
* can sustain a ringing artifact of its own. Measuring an oscillation under
* the damping integrator is the conservative choice -- a positive result
* here cannot be an artifact of the integrator, because the integrator is
* biased against it. reltol/abstol/vntol/chgtol stay at ngspice defaults.
*
* The 200 ns maximum timestep is ~10 points per period of the ~500 kHz
* activity this bench was written to catch. It is load-bearing, not a
* performance knob: Gear integration is damping, so a coarser ceiling damps
* the signal being measured (verified at tt/27C/3.30V -- a 400 ns ceiling
* reports 37 nV pk-pk on the heavy branch where 200 ns reports 3.31 V).
*
* ---------------------------------------------------------------------------
* Why there IS a stimulus, and why it is outside the measurement window
* ---------------------------------------------------------------------------
* An unstable loop started only by the integrator's own truncation noise
* grows from whatever that noise happens to be, so how far it has grown by a
* given time is not reproducible run to run -- measured, the light branch
* reads 1.21 V pk-pk in one window and sub-microvolt in another on the SAME
* netlist, purely because the two runs' timestep sequences seed it
* differently. A negative would then be unfalsifiable.
*
* Ikick_* fixes that: a 1 nA, 1 us current pulse into each pass gate at
* t = 10 us, i.e. 190 us (about 95 periods) before the measurement window
* opens. It is far too small to be a stimulus in any meaningful sense -- the
* pass gate node sits at a ~20 kOhm buffer output, so 1 nA is ~20 uV of
* excitation -- but it is a DEFINED seed, identical at every corner, so the
* measured peak-to-peak is a statement about the loop's response to a
* perturbation rather than about the integrator's noise. A stable loop
* returns to its operating point long before the window opens; an unstable
* one has grown to its limit cycle. Both branches are seeded identically so
* the light and heavy readings are comparable.

.options method=gear
Vsup VIN 0 DC {vdd_val}
Ven  EN  0 DC {vdd_val}

Xdut_light VIN VOUT_LIGHT EN 0 LOOP_LIGHT LOOP_LIGHT ldo_core
Rload_light VOUT_LIGHT 0 18k
Resr_light  VOUT_LIGHT n_esr_light 0.001
Cout_light  n_esr_light 0 0.33u

Xdut_heavy VIN VOUT_HEAVY EN 0 LOOP_HEAVY LOOP_HEAVY ldo_core
Rload_heavy VOUT_HEAVY 0 36
Resr_heavy  VOUT_HEAVY n_esr_heavy 0.001
Cout_heavy  n_esr_heavy 0 0.33u

* Deterministic seed -- see the header. 1 nA for 1 us at t = 10 us, which is
* 190 us before the measurement window opens.
Ikick_light 0 LOOP_LIGHT PULSE(0 1n 10u 1n 1n 1u 1)
Ikick_heavy 0 LOOP_HEAVY PULSE(0 1n 10u 1n 1n 1u 1)
