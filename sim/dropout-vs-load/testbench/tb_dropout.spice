* dropout-vs-load -- stimulus fragment for ldo_core (issue #12)
*
* Measures dropout voltage at the ratified 50 mA full-load spec point. Per
* spec/decision-records/DR-0004-spec-ratification.md note 4, dropout is
* measured at Vin = Vout + dropout ~= 2.10 V, not at the +/-10% supply floor
* (2.97 V) -- undersizing from the 2.97 V rows undersizes the pass device by
* ~50% (sim/devchar/CONCLUSIONS.md Sec.1). The harness's normal supply grid
* is collapsed via tb.json's nominal_supply_v/supply_tolerance (see the
* recorded --subset-reason); the supply axis is instead the swept variable of
* the measurement itself.
*
* HOW DROPOUT IS MEASURED HERE (changed by #138 / DR-0017): the manifest
* sweeps Vsup down through the regulation knee at a fixed 50 mA load and
* reports the Vin - Vout headroom at the point where Vout has fallen to the
* ratified -2% accuracy edge (1.764 V). It does NOT report v(vin)-v(vout) at
* a pinned Vin = 2.10 V, which is what this deck's manifest asked for until
* #138: because the ratified test point *is* Vout_nom + the ratified bound
* (2.10 = 1.800 + 0.300), that expression is identically 300 mV + (1.800 V -
* Vout) while the loop is in regulation -- the DC regulation error offset by
* exactly the bound, not the dropout voltage. Nothing in the netlist below
* changed for #138; the whole correction lives in tb.json's analyses/measure.
*
* EN is tied directly to VIN at instantiation (same net used twice), which
* wires Vgs=0 at the enable clamp -- the "enabled" state -- without a
* separate source. EN therefore tracks the swept Vin, which is the intended
* condition: a real supply brownout takes the enable input down with it.
Vsup VIN 0 DC {vdd_val}
Xdut VIN VOUT VIN 0 LOOP LOOP ldo_core

* --- 50 mA compliance-limited load sink -- the full-load dropout point
* (README.md Target specification, "Dropout @ 50 mA" row). Output network
* per DR-0001's window (1.0 uF nominal + 100 mOhm ESR); inert at this DC
* operating point.
*
* This is the same sink #46/#49 put into load-regulation, line-regulation,
* load-transient, psrr-vs-freq and quiescent-current, and for the same
* reason: an IDEAL sink demands its current at any terminal voltage,
* including tens of volts below ground, where forward-biased substrate
* junctions inside the PDK models supply it. That is a genuine second DC
* solution of this deck, not a convergence failure. This experiment was the
* one #46 left on an ideal sink plus a `.nodeset` hint, because the hint
* happened to steer all 15 of its points into the physical basin against
* the DUT of the day; it does not survive a change to the pass-gate drive
* node (issue #51's buffer), which is exactly the fragility #40 flagged.
* Bounding the sink at 0 V deletes the branch instead of hiding it. See
* sim/harness/README.md, "Compliance-limited load sinks".
*
*     f(VOUT) = 0.5 * (1 + tanh((VOUT - 0.2) / 0.05))
*
* At the ~1.8 V this design regulates to -- and still at the ~1.46 V the
* output falls to at the bottom of the Vin sweep, deep in dropout -- 1 - f is
* below double precision, so the sink is an ideal 50 mA current sink at every
* operating point this record reports; i(Vlmeas) is measured and checked
* against the commanded 50 mA so that stays verified rather than assumed.
Vilc ILC 0 DC 50m
Bload VOUT NLOAD I = 'v(ilc) * 0.5 * (1 + tanh((v(vout) - 0.2) / 0.05))'
Vlmeas NLOAD 0 DC 0
Resr VOUT n_esr 0.1
Cout n_esr 0 1u
