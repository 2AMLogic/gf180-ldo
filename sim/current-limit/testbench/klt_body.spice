* current-limit -- klt sim circuit body (issue #320).
*
* Constant-current (brickwall) limit characterization for ldo_core with
* Xilimit (issue #11). Substantiates the ratified "Current limit" row of
* README.md's target specification: threshold over PVT, constant-current
* (not folded-back) behaviour, and -- the safety-critical half -- that the
* limit never engages for I_load in [0, 50] mA at any corner.
*
* The shape `klt sim` accepts: a circuit body with no .control block and ONE
* analysis per corner (see sim/harness/klt_batch.py for why this exists).
* The two claims are taken at the SAME PVT point as two INDEPENDENT ldo_core
* instances sharing only ideal sources (Vin, Vref, and the EN follower), and
* one `dc` sweep of Vforce walks the V-I instance down the characteristic
* while the regulation instance -- which nothing in the sweep touches -- is
* read at any point:
*
*   Xreg  regulation mode: 36 ohm resistive load (~50 mA at 1.8 V), no
*         forcing. Answers "is the output still in the +/-2% window at
*         50 mA?", i.e. did the limit engage inside the rated load range.
*   Xvi   V-I mode: VOUT forced through 1 mohm, swept 0 -> 1.764 V in 12 mV
*         steps, so 0, 0.3, 0.9, 1.5 and 1.764 V are EXACT sweep points
*         (indices 0, 25, 75, 125, 147); the measurements in klt_run.py
*         index them directly rather than interpolate. Sweeping the forced
*         VOUT down to a dead short traces the whole current-limit
*         characteristic: its FLATNESS is the brickwall claim, and its
*         value at 1.764 V (the edge of the +/-2% window) is the threshold.
*
* Both load styles are RESISTIVE or VOLTAGE-FORCED, never an ideal current
* sink, and that is deliberate. With an ideal current sink the only DC paths
* left at VOUT are the feedback divider (300 kohm) and the sense/threshold
* resistors, so the node's DC impedance is enormous and the operating-point
* solve is badly conditioned: sweeping a current sink from 0 to 55 mA on
* this circuit returns physically absurd answers (Vout = -64 V at 2 mA,
* +1.802 V at 6 mA, -3.5 V at 15 mA) that are solver artifacts, not a
* bistable circuit. A resistor cannot pull the output below ground and
* keeps the node's impedance bounded, so every point converges to the
* physical branch. The load current is measured (Vlmeas) rather than
* assumed, since a resistive load's current depends on the settled Vout.
*
* 1 mohm at 90 mA is a 90 uV error on the forced node and 1 Gohm at 1.8 V
* leaks 1.8 nA: both are far below anything measured here.
*
* ERRAMP_OUT and PASS_GATE are ldo_core's deliberately separate loop-break
* ports; normal operation ties them together at instantiation (nets
* LOOP_R / LOOP_V), exactly as sim/op-point-sanity does. See design/README.md.
*
* VREF is a TOP-LEVEL PORT of ldo_core (issue #174 / DR-0021) driven here by
* an ideal 1.2 V source: electrically the no-op that move was proven to be,
* with the idealization visible at the interface so a real reference (a
* bandgap block, or the Chipalooza Challenge #5 harness's bandgap-referenced
* bias-voltage slot) can drive it without editing the schematic. One source
* serves every DUT instance: an ideal source has zero output impedance, so
* instances cannot interact through it.
*
* EN follows VIN through an ideal VCVS so the request's supply axis can
* `alter vin` alone.
*
* Retired 0 mA / 25 mA points (#595): this bench's bash-driven predecessor
* (removed by the same issue) also took four ungraded diagnostic values --
* Vout and I(Vin) at 0 mA external load, Vout and Iload at 25 mA. They were
* retired, not ported: none is a graded spec row, and no klt-path record
* under sim/current-limit/corners/ ever carried them. The surviving
* benches do NOT re-cover these two load points; their actual coverage is
* narrower. The quiescent-current bench grades the enabled no-load supply
* current (its iq_en_ua claim). The load-regulation bench sweeps
* `dc Vilc 1m 50m 7m` (neither 0 mA nor 25 mA is a sweep point) and grades
* only the 1 mA-to-50 mA endpoint drift against 18 mV, plus 1.7-1.9 V
* harness-integrity bounds on the two endpoint voltages -- not absolute
* output accuracy across the 0-50 mA range. What is dropped is therefore
* the ungraded 0 mA and 25 mA diagnostic values themselves.

.include "dut.spice"

Vin VIN 0 DC 3.3
Een EN 0 VIN 0 1
Vref VREF 0 DC 1.2

* regulation instance
Xreg VIN VOUT_R EN 0 LOOP_R LOOP_R VREF ldo_core
Rload_r VOUT_R LN_R 36
Vlmeas_r LN_R 0 DC 0

* V-I instance
Xvi VIN VOUT_V EN 0 LOOP_V LOOP_V VREF ldo_core
Vforce VF 0 DC 0
Rforce VOUT_V VF 1m
