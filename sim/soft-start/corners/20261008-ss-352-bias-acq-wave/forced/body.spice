.param sw_stat_global=0 sw_stat_mismatch=0 mc_skew=3 res_mc_skew=3 cap_mc_skew=3 fnoicor=0
.options wnflag=1
* issue-352 bias-acquisition scenario: forced (generated by bias_acq.py)
.include "dut.spice"
.options reltol=1e-3 vntol=1e-5 abstol=1e-11 chgtol=1e-14
Vin VIN 0 DC 3.3
Een EN 0 VIN 0 1
Vref VREF 0 DC 1.2
Xdut VIN VOUT EN 0 EOUT PG VREF ldo_core
Vhold HOLD_ACQ 0 DC 1 PWL(0 1 20u 1 20.01u 0)
Bacq_il_w1 ACQ_IL_W1 0 V = 'v(xdut.xilimit.vx) - 1.188 + 10 * (time >= 0.000169)'
Bacq_ss_w1 ACQ_SS_W1 0 V = 'v(xdut.xsoftstart.vx_ss) - 1.188 + 10 * (time >= 0.000169)'
Vloop PG EOUT DC 0
Resr VOUT n_esr 0.1
Cout n_esr 0 1u
Rload VOUT 0 36
