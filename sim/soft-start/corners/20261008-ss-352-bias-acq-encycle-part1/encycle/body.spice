.param sw_stat_global=0 sw_stat_mismatch=0 mc_skew=3 res_mc_skew=3 cap_mc_skew=3 fnoicor=0
.options wnflag=1
* issue-352 bias-acquisition scenario: encycle (generated by bias_acq.py)
.include "dut.spice"
.options reltol=1e-3 vntol=1e-5 abstol=1e-11 chgtol=1e-14
Vin VIN 0 DC 3.3
Venctl ENCTL 0 DC 0 PWL(0 0 20u 0 20.01u 1 170u 1 170.01u 0 270u 0 270.01u 1 420u 1 420.01u 0 421u 0 421.01u 1 570u 1 570.01u 0 580u 0 580.01u 1)
Ben EN 0 V = 'v(vin) * v(enctl)'
Vref VREF 0 DC 1.2
Xdut VIN VOUT EN 0 EOUT PG VREF ldo_core
Bacq_il_w1 ACQ_IL_W1 0 V = 'v(xdut.xilimit.vx) - 1.188 + 10 * (time >= 0.000169)'
Bacq_ss_w1 ACQ_SS_W1 0 V = 'v(xdut.xsoftstart.vx_ss) - 1.188 + 10 * (time >= 0.000169)'
Bacq_il_w2 ACQ_IL_W2 0 V = 'v(xdut.xilimit.vx) - 1.188 + 10 * (time >= 0.000419)'
Bacq_ss_w2 ACQ_SS_W2 0 V = 'v(xdut.xsoftstart.vx_ss) - 1.188 + 10 * (time >= 0.000419)'
Bacq_il_w3 ACQ_IL_W3 0 V = 'v(xdut.xilimit.vx) - 1.188 + 10 * (time >= 0.000569)'
Bacq_ss_w3 ACQ_SS_W3 0 V = 'v(xdut.xsoftstart.vx_ss) - 1.188 + 10 * (time >= 0.000569)'
Bacq_il_w4 ACQ_IL_W4 0 V = 'v(xdut.xilimit.vx) - 1.188 + 10 * (time >= 0.000729)'
Bacq_ss_w4 ACQ_SS_W4 0 V = 'v(xdut.xsoftstart.vx_ss) - 1.188 + 10 * (time >= 0.000729)'
Vloop PG EOUT DC 0
Resr VOUT n_esr 0.1
Cout n_esr 0 1u
Rload VOUT 0 36
