.param sw_stat_global=0 sw_stat_mismatch=0 mc_skew=3 res_mc_skew=3 cap_mc_skew=3 fnoicor=0
.options wnflag=1
* issue-352 bias-acquisition scenario: powerup (generated by bias_acq.py)
.include "dut.spice"
.options reltol=1e-3 vntol=1e-5 abstol=1e-11 chgtol=1e-14
Vin VIN 0 DC 3.3
Vpu PU 0 DC 0 PWL(0 0 10u 0 110u 1)
Bvinr VINR 0 V = 'v(vin) * v(pu)'
Een EN 0 VINR 0 1
Vref VREF 0 DC 1.2
Xdut VINR VOUT EN 0 EOUT PG VREF ldo_core
Bacq_il_w1 ACQ_IL_W1 0 V = 'v(xdut.xilimit.vx) - 1.188 + 10 * (time >= 0.000259)'
Bacq_ss_w1 ACQ_SS_W1 0 V = 'v(xdut.xsoftstart.vx_ss) - 1.188 + 10 * (time >= 0.000259)'
Vloop PG EOUT DC 0
Resr VOUT n_esr 0.1
Cout n_esr 0 1u
Rload VOUT 0 36
