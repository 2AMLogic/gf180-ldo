.param sw_stat_global=0 sw_stat_mismatch=0 mc_skew=3 res_mc_skew=3 cap_mc_skew=3 fnoicor=0
.options wnflag=1
* issue-352 bias-acquisition scenario: op (generated by bias_acq.py)
.include "dut.spice"
Vin VIN 0 DC 3.3
Vdum DUM 0 DC 0
Rdum DUM 0 1k  $ dummy sweep source, connected to nothing else
Een EN 0 VIN 0 1
Vref VREF 0 DC 1.2
Xdut VIN VOUT EN 0 EOUT PG VREF ldo_core
Vloop PG EOUT DC 0
Resr VOUT n_esr 0.1
Cout n_esr 0 1u
Rload VOUT 0 36
