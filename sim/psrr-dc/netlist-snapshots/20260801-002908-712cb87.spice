* Frozen netlist snapshot for record 20260801-002908-712cb87
* This is a verbatim copy taken at record time. Do not edit.

* ======================================================================
* included design cell : design/netlist/error_amp.spice
* sha256               : bd5b85cc794710c4f530e40949cc2a3d0d34ea953006024a94d48a0650774650
* ======================================================================
* error_amp -- generated by design/netlist.py from design/error_amp.sch
* Do not edit: edit the schematic and re-run the export.
** sch_path: design/error_amp.sch
.subckt error_amp INP INN OUT VDD VSS
*.PININFO INP:I INN:I OUT:O VDD:B VSS:B
XRbias NBIAS VDD VSS ppolyf_u_1k r_width=1u r_length=1000u m=1
XMB1 NBIAS NBIAS VSS VSS nfet_03v3 L=4u W=6u nf=1 ad='int((nf+1)/2) * W/nf * 0.18u' as='int((nf+2)/2) * W/nf * 0.18u' pd='2*int((nf+1)/2) * (W/nf + 0.18u)'
+ ps='2*int((nf+2)/2) * (W/nf + 0.18u)' nrd='0.18u / W' nrs='0.18u / W' sa=0 sb=0 sd=0 m=1
XMTAIL TAIL NBIAS VSS VSS nfet_03v3 L=4u W=6u nf=1 ad='int((nf+1)/2) * W/nf * 0.18u' as='int((nf+2)/2) * W/nf * 0.18u' pd='2*int((nf+1)/2) * (W/nf + 0.18u)'
+ ps='2*int((nf+2)/2) * (W/nf + 0.18u)' nrd='0.18u / W' nrs='0.18u / W' sa=0 sb=0 sd=0 m=1
XMIN1 ND INN TAIL VSS nfet_03v3 L=6u W=60u nf=6 ad='int((nf+1)/2) * W/nf * 0.18u' as='int((nf+2)/2) * W/nf * 0.18u' pd='2*int((nf+1)/2) * (W/nf + 0.18u)'
+ ps='2*int((nf+2)/2) * (W/nf + 0.18u)' nrd='0.18u / W' nrs='0.18u / W' sa=0 sb=0 sd=0 m=1
XMIN2 N1 INP TAIL VSS nfet_03v3 L=6u W=60u nf=6 ad='int((nf+1)/2) * W/nf * 0.18u' as='int((nf+2)/2) * W/nf * 0.18u' pd='2*int((nf+1)/2) * (W/nf + 0.18u)'
+ ps='2*int((nf+2)/2) * (W/nf + 0.18u)' nrd='0.18u / W' nrs='0.18u / W' sa=0 sb=0 sd=0 m=1
XMLD1 ND ND VDD VDD pfet_03v3 L=8u W=8u nf=1 ad='int((nf+1)/2) * W/nf * 0.18u' as='int((nf+2)/2) * W/nf * 0.18u' pd='2*int((nf+1)/2) * (W/nf + 0.18u)'
+ ps='2*int((nf+2)/2) * (W/nf + 0.18u)' nrd='0.18u / W' nrs='0.18u / W' sa=0 sb=0 sd=0 m=1
XMLD2 N1 ND VDD VDD pfet_03v3 L=8u W=8u nf=1 ad='int((nf+1)/2) * W/nf * 0.18u' as='int((nf+2)/2) * W/nf * 0.18u' pd='2*int((nf+1)/2) * (W/nf + 0.18u)'
+ ps='2*int((nf+2)/2) * (W/nf + 0.18u)' nrd='0.18u / W' nrs='0.18u / W' sa=0 sb=0 sd=0 m=1
XRz NZ N1 VSS ppolyf_u r_width=1u r_length=109u m=1
XCc NZ OUT cap_mim_2f0_m2m3_noshield c_width=39u c_length=39u m=1
XM2P OUT N1 VDD VDD pfet_03v3 L=2u W=150u nf=15 ad='int((nf+1)/2) * W/nf * 0.18u' as='int((nf+2)/2) * W/nf * 0.18u' pd='2*int((nf+1)/2) * (W/nf + 0.18u)'
+ ps='2*int((nf+2)/2) * (W/nf + 0.18u)' nrd='0.18u / W' nrs='0.18u / W' sa=0 sb=0 sd=0 m=1
XM2N OUT NBIAS VSS VSS nfet_03v3 L=4u W=10u nf=1 ad='int((nf+1)/2) * W/nf * 0.18u' as='int((nf+2)/2) * W/nf * 0.18u' pd='2*int((nf+1)/2) * (W/nf + 0.18u)'
+ ps='2*int((nf+2)/2) * (W/nf + 0.18u)' nrd='0.18u / W' nrs='0.18u / W' sa=0 sb=0 sd=0 m=1
.ends

* ======================================================================
* testbench fragment   : sim/psrr-dc/testbench/tb_psrr_amp.spice
* sha256               : 936d96b147c7ce01bd90cdabc6e35fe960aee45791f93d8c4b2a305cdc10f57c
* ======================================================================
* tb_psrr_amp -- the error amplifier's own contribution to LDO PSRR at 1 kHz
* (design/error_amp.sch, issue #9). AMP LEVEL ONLY: the closed-loop PSRR claim
* needs the pass device, the divider and the output network, and belongs to
* #12's testbench suite.
*
* Netlist FRAGMENT. The harness supplies the title, the gf180mcu model
* .include, the corner .lib sections, .temp, the .control block and .end, and
* emits the .include of design/netlist/error_amp.spice from tb.json's
* "includes". Amp pinout: INP INN OUT VDD VSS (#8's ratified contract), INP
* non-inverting (= FB), INN inverting (= VREF).
*
* ---------------------------------------------------------------------------
* Why two numbers, not one
* ---------------------------------------------------------------------------
* Small-signal, with the pass device's source on VIN and its gate on the amp
* output, and writing G = dVout_amp/dVdd (how well the amp's output rides the
* supply) and A = the amp's gain from the feedback node:
*
*   vout/vdd = [gm_p*(1 - G) + 1/ro_p] / (1/Zout + 1/ro_p + gm_p*A*beta)
*            ~= (1 - G) / (A * beta)                (loop term dominates)
*
* so
*
*   PSRR(f) ~= A(f) * beta / |1 - G(f)|
*
* Both factors are amplifier properties and both are measured here:
*
*   A(f)  from X2 -- AC on the feedback input, supply quiet
*   G(f)  from X1 -- AC on the supply, inputs quiet
*
* Note the load-independence: Zout, ro_p and gm_p all cancel, which is why the
* PSRR budget lands on amp gain and bandwidth (spec/architecture-survey.md
* S3.2, S5) rather than on the pass-device topology. G = 0 is the pessimistic
* case (gate pinned while VIN moves, full Vsg ripple); G -> 1 means the gate
* rides the supply and the pass device sees no Vsg ripple at all. The recorded
* PSRR number is the BUDGETED one, A*beta with |1-G| forced to 1; the measured
* tracking term is reported separately as unbudgeted margin.
*
* Both instances are held at their operating point by the same DC-only servo
* used in sim/amp-openloop (1 TH inductor short at DC / open at AC, level
* shifted so OUT parks at 2.0 V, with a 1 F cap making INN an AC ground). The
* servo is a DC artefact only: its pole sits at 1/(2*pi*1e12*1) ~ 0.16 pHz, so
* it is inert everywhere in the measured band and cannot flatter the result.
* That also means DC PSRR is not measurable on this bench -- the servo nulls
* it by construction -- which is fine: the spec point is 1 kHz.
*
* The amplifier is self-biased from VDD (there is no bias pin), so the bias
* generator's own supply sensitivity IS included in G here -- it is not
* idealised away.

.param cgate=6.14p
.param vcm=1.2
.param vg_op=2.0

* ==== X1: AC on the supply, inputs quiet -> G = dVout_amp/dVdd ==============
Vsup1 vdd1  0 dc {vdd_val} ac 1
Vfb1  nfb1  0 dc {vcm}
Lfb1  vg1   nls1 1T
Vls1  nls1  nref1 dc {vg_op-vcm}
Cref1 nref1 0 1
Cl1   vg1   0 {cgate}
X1 nfb1 nref1 vg1 vdd1 0 error_amp

* ==== X2: AC on the feedback input, supply quiet -> A =======================
Vsup2 vdd2  0 dc {vdd_val}
Vfb2  nfb2  0 dc {vcm} ac 1
Lfb2  vg2   nls2 1T
Vls2  nls2  nref2 dc {vg_op-vcm}
Cref2 nref2 0 1
Cl2   vg2   0 {cgate}
X2 nfb2 nref2 vg2 vdd2 0 error_amp
