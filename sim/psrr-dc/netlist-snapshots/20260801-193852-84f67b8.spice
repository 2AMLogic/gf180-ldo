* Frozen netlist snapshot for record 20260801-193852-84f67b8
* This is a verbatim copy taken at record time. Do not edit.

* ======================================================================
* included design cell : design/netlist/error_amp.spice
* sha256               : debf3700be977532a4978528850bae66579f365d41dbc7c8bbbb0c06b8d7f903
* ======================================================================
* error_amp -- generated by design/netlist.py from design/error_amp.sch
* Do not edit: edit the schematic and re-run the export.
** sch_path: design/error_amp.sch
.subckt error_amp INP INN OUT VDD VSS EN
*.PININFO INP:I INN:I OUT:O VDD:B VSS:B EN:I
XRbias NBIAS RBT VSS ppolyf_u_1k r_width=1u r_length=1000u m=1
XMB1 NBIAS NBIAS VSS VSS nfet_03v3 L=4u W=6u nf=1 ad='int((nf+1)/2) * W/nf * 0.18u' as='int((nf+2)/2) * W/nf * 0.18u' pd='2*int((nf+1)/2) * (W/nf + 0.18u)'
+ ps='2*int((nf+2)/2) * (W/nf + 0.18u)' nrd='0.18u / W' nrs='0.18u / W' sa=0 sb=0 sd=0 m=1
XMTAIL TAIL NBIAS VSS VSS nfet_03v3 L=4u W=6u nf=1 ad='int((nf+1)/2) * W/nf * 0.18u' as='int((nf+2)/2) * W/nf * 0.18u' pd='2*int((nf+1)/2) * (W/nf + 0.18u)'
+ ps='2*int((nf+2)/2) * (W/nf + 0.18u)' nrd='0.18u / W' nrs='0.18u / W' sa=0 sb=0 sd=0 m=1
XMIN1 ND INN TAIL VSS nfet_03v3 L=6u W=60u nf=6 ad='int((nf+1)/2) * W/nf * 0.18u' as='int((nf+2)/2) * W/nf * 0.18u' pd='2*int((nf+1)/2) * (W/nf + 0.18u)'
+ ps='2*int((nf+2)/2) * (W/nf + 0.18u)' nrd='0.18u / W' nrs='0.18u / W' sa=0 sb=0 sd=0 m=1
XMIN2 N1 INP TAIL VSS nfet_03v3 L=6u W=60u nf=6 ad='int((nf+1)/2) * W/nf * 0.18u' as='int((nf+2)/2) * W/nf * 0.18u' pd='2*int((nf+1)/2) * (W/nf + 0.18u)'
+ ps='2*int((nf+2)/2) * (W/nf + 0.18u)' nrd='0.18u / W' nrs='0.18u / W' sa=0 sb=0 sd=0 m=1
XMLD1 ND ND VDD VDD pfet_03v3 L=8u W=8u nf=1 ad='int((nf+1)/2) * W/nf * 0.18u' as='int((nf+2)/2) * W/nf * 0.18u' pd='2*int((nf+1)/2) * (W/nf + 0.18u)'
+ ps='2*int((nf+2)/2) * (W/nf + 0.18u)' nrd='0.18u / W' nrs='0.18u / W' sa=0 sb=0 sd=0 m=1
XMLD2 N1 ND VDD VDD pfet_03v3 L=8u W=8u nf=1 ad='int((nf+1)/2) * W/nf * 0.18u' as='int((nf+2)/2) * W/nf * 0.18u' pd='2*int((nf+1)/2) * (W/nf + 0.18u)'
+ ps='2*int((nf+2)/2) * (W/nf + 0.18u)' nrd='0.18u / W' nrs='0.18u / W' sa=0 sb=0 sd=0 m=1
XRz NZ N1 VSS ppolyf_u_1k r_width=1u r_length=6000u m=1
XCc NZ OUT cap_mim_2f0_m2m3_noshield c_width=49u c_length=49u m=1
XM2P BG N1 VDD VDD pfet_03v3 L=2u W=150u nf=15 ad='int((nf+1)/2) * W/nf * 0.18u' as='int((nf+2)/2) * W/nf * 0.18u' pd='2*int((nf+1)/2) * (W/nf + 0.18u)'
+ ps='2*int((nf+2)/2) * (W/nf + 0.18u)' nrd='0.18u / W' nrs='0.18u / W' sa=0 sb=0 sd=0 m=1
XM2N BG NBIAS VSS VSS nfet_03v3 L=4u W=4u nf=1 ad='int((nf+1)/2) * W/nf * 0.18u' as='int((nf+2)/2) * W/nf * 0.18u' pd='2*int((nf+1)/2) * (W/nf + 0.18u)'
+ ps='2*int((nf+2)/2) * (W/nf + 0.18u)' nrd='0.18u / W' nrs='0.18u / W' sa=0 sb=0 sd=0 m=1
XRbufb NBP N1 VSS ppolyf_u_1k r_width=1u r_length=5000u m=1
XMbufb OUT NBP VDD VDD pfet_03v3 L=2u W=200u nf=20 ad='int((nf+1)/2) * W/nf * 0.18u' as='int((nf+2)/2) * W/nf * 0.18u' pd='2*int((nf+1)/2) * (W/nf + 0.18u)'
+ ps='2*int((nf+2)/2) * (W/nf + 0.18u)' nrd='0.18u / W' nrs='0.18u / W' sa=0 sb=0 sd=0 m=1
XMbuf OUT BG VSS OUT pfet_03v3 L=1u W=150u nf=15 ad='int((nf+1)/2) * W/nf * 0.18u' as='int((nf+2)/2) * W/nf * 0.18u' pd='2*int((nf+1)/2) * (W/nf + 0.18u)'
+ ps='2*int((nf+2)/2) * (W/nf + 0.18u)' nrd='0.18u / W' nrs='0.18u / W' sa=0 sb=0 sd=0 m=1
XMpgn OUT NBIAS VSS VSS nfet_03v3 L=8u W=2u nf=1 ad='int((nf+1)/2) * W/nf * 0.18u' as='int((nf+2)/2) * W/nf * 0.18u' pd='2*int((nf+1)/2) * (W/nf + 0.18u)'
+ ps='2*int((nf+2)/2) * (W/nf + 0.18u)' nrd='0.18u / W' nrs='0.18u / W' sa=0 sb=0 sd=0 m=1
XMbg_pu BG EN VDD VDD pfet_03v3 L=0.5u W=4u nf=1 ad='int((nf+1)/2) * W/nf * 0.18u' as='int((nf+2)/2) * W/nf * 0.18u' pd='2*int((nf+1)/2) * (W/nf + 0.18u)'
+ ps='2*int((nf+2)/2) * (W/nf + 0.18u)' nrd='0.18u / W' nrs='0.18u / W' sa=0 sb=0 sd=0 m=1
XMinv_p ENB EN VDD VDD pfet_03v3 L=0.5u W=4u nf=1 ad='int((nf+1)/2) * W/nf * 0.18u' as='int((nf+2)/2) * W/nf * 0.18u' pd='2*int((nf+1)/2) * (W/nf + 0.18u)'
+ ps='2*int((nf+2)/2) * (W/nf + 0.18u)' nrd='0.18u / W' nrs='0.18u / W' sa=0 sb=0 sd=0 m=1
XMinv_n ENB EN VSS VSS nfet_03v3 L=0.5u W=2u nf=1 ad='int((nf+1)/2) * W/nf * 0.18u' as='int((nf+2)/2) * W/nf * 0.18u' pd='2*int((nf+1)/2) * (W/nf + 0.18u)'
+ ps='2*int((nf+2)/2) * (W/nf + 0.18u)' nrd='0.18u / W' nrs='0.18u / W' sa=0 sb=0 sd=0 m=1
XMbias_h RBT ENB VDD VDD pfet_03v3 L=0.5u W=20u nf=1 ad='int((nf+1)/2) * W/nf * 0.18u' as='int((nf+2)/2) * W/nf * 0.18u' pd='2*int((nf+1)/2) * (W/nf + 0.18u)'
+ ps='2*int((nf+2)/2) * (W/nf + 0.18u)' nrd='0.18u / W' nrs='0.18u / W' sa=0 sb=0 sd=0 m=1
XMnb_pd NBIAS ENB VSS VSS nfet_03v3 L=0.5u W=10u nf=1 ad='int((nf+1)/2) * W/nf * 0.18u' as='int((nf+2)/2) * W/nf * 0.18u' pd='2*int((nf+1)/2) * (W/nf + 0.18u)'
+ ps='2*int((nf+2)/2) * (W/nf + 0.18u)' nrd='0.18u / W' nrs='0.18u / W' sa=0 sb=0 sd=0 m=1
XMn1_pu N1 EN VDD VDD pfet_03v3 L=0.5u W=4u nf=1 ad='int((nf+1)/2) * W/nf * 0.18u' as='int((nf+2)/2) * W/nf * 0.18u' pd='2*int((nf+1)/2) * (W/nf + 0.18u)'
+ ps='2*int((nf+2)/2) * (W/nf + 0.18u)' nrd='0.18u / W' nrs='0.18u / W' sa=0 sb=0 sd=0 m=1
XMnd_pu ND EN VDD VDD pfet_03v3 L=0.5u W=4u nf=1 ad='int((nf+1)/2) * W/nf * 0.18u' as='int((nf+2)/2) * W/nf * 0.18u' pd='2*int((nf+1)/2) * (W/nf + 0.18u)'
+ ps='2*int((nf+2)/2) * (W/nf + 0.18u)' nrd='0.18u / W' nrs='0.18u / W' sa=0 sb=0 sd=0 m=1
.ends

* ======================================================================
* testbench fragment   : sim/psrr-dc/testbench/tb_psrr_amp.spice
* sha256               : c8ba4f0a3c270fe150800d977c3105e131151e724117af46e5a455bfea68535a
* ======================================================================
* tb_psrr_amp -- the error amplifier's own contribution to LDO PSRR at 1 kHz
* (design/error_amp.sch, issue #9). AMP LEVEL ONLY: the closed-loop PSRR claim
* needs the pass device, the divider and the output network, and belongs to
* #12's testbench suite.
*
* Netlist FRAGMENT. The harness supplies the title, the gf180mcu model
* .include, the corner .lib sections, .temp, the .control block and .end, and
* emits the .include of design/netlist/error_amp.spice from tb.json's
* "includes". Amp pinout: INP INN OUT VDD VSS (#8's ratified contract), INP
*
* EN (sixth port, appended by issue #11): each instance's EN is tied to ITS
* OWN vdd node, i.e. the amplifier is enabled, which is the only state this
* bench characterizes. That is also the physically honest wiring -- a real
* enable is driven by CMOS logic on the same supply -- and it matters here
* because EN is not a quiet node: it gates a local inverter whose output
* holds the bias header's gate. Tying EN to a clean, separate source would
* hide any supply coupling that path contributes.
* non-inverting (= FB), INN inverting (= VREF).
*
* ---------------------------------------------------------------------------
* Why two numbers, not one
* ---------------------------------------------------------------------------
* Small-signal, with the pass device's source on VIN and its gate on the amp
* output, and writing G = dVout_amp/dVdd (how well the amp's output rides the
* supply) and A = the amp's gain from the feedback node:
*
*   vout/vdd = [gm_p*(1 - G) + 1/ro_p] / (1/Zout + 1/ro_p + gm_p*A*beta)
*            ~= (1 - G) / (A * beta)                (loop term dominates)
*
* so
*
*   PSRR(f) ~= A(f) * beta / |1 - G(f)|
*
* Both factors are amplifier properties and both are measured here:
*
*   A(f)  from X2 -- AC on the feedback input, supply quiet
*   G(f)  from X1 -- AC on the supply, inputs quiet
*
* Note the load-independence: Zout, ro_p and gm_p all cancel, which is why the
* PSRR budget lands on amp gain and bandwidth (spec/architecture-survey.md
* S3.2, S5) rather than on the pass-device topology. G = 0 is the pessimistic
* case (gate pinned while VIN moves, full Vsg ripple); G -> 1 means the gate
* rides the supply and the pass device sees no Vsg ripple at all. The recorded
* PSRR number is the BUDGETED one, A*beta with |1-G| forced to 1; the measured
* tracking term is reported separately as unbudgeted margin.
*
* Both instances are held at their operating point by the same DC-only servo
* used in sim/amp-openloop (1 TH inductor short at DC / open at AC, level
* shifted so OUT parks at 2.0 V, with a 1 F cap making INN an AC ground). The
* servo is a DC artefact only: its pole sits at 1/(2*pi*1e12*1) ~ 0.16 pHz, so
* it is inert everywhere in the measured band and cannot flatter the result.
* That also means DC PSRR is not measurable on this bench -- the servo nulls
* it by construction -- which is fine: the spec point is 1 kHz.
*
* The amplifier is self-biased from VDD (there is no bias pin), so the bias
* generator's own supply sensitivity IS included in G here -- it is not
* idealised away.

.param cgate=6.14p
.param vcm=1.2
.param vg_op=2.0

* ==== X1: AC on the supply, inputs quiet -> G = dVout_amp/dVdd ==============
Vsup1 vdd1  0 dc {vdd_val} ac 1
Vfb1  nfb1  0 dc {vcm}
Lfb1  vg1   nls1 1T
Vls1  nls1  nref1 dc {vg_op-vcm}
Cref1 nref1 0 1
Cl1   vg1   0 {cgate}
X1 nfb1 nref1 vg1 vdd1 0 vdd1 error_amp

* ==== X2: AC on the feedback input, supply quiet -> A =======================
Vsup2 vdd2  0 dc {vdd_val}
Vfb2  nfb2  0 dc {vcm} ac 1
Lfb2  vg2   nls2 1T
Vls2  nls2  nref2 dc {vg_op-vcm}
Cref2 nref2 0 1
Cl2   vg2   0 {cgate}
X2 nfb2 nref2 vg2 vdd2 0 vdd2 error_amp
