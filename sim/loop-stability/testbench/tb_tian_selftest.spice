* tb_tian_selftest -- does the loop-gain extraction actually measure the loop gain?
*
* The stability record this experiment produces is only worth what the
* extraction method is worth, so this deck checks the method against a loop
* whose gain is known in closed form, and deliberately sets up the exact
* condition (Z_source >> Z_load at the break) under which the *naive* method
* -- plain series-voltage injection -- is wrong. If the arithmetic in
* tb_loop_stability.spice.in were wrong, this deck would not agree with
* theory; if plain voltage injection were good enough, this deck would show
* no difference between the two.
*
* Reference loop (all ideal elements, no PDK devices, so the answer is exact):
*
*        +--------------------- Egain ------------------------+
*        |   E = -A/(1+s/wp) * V(fb)                          |
*        v                                                    |
*   [ Rs ] --- A_node ==BREAK== B_node --- [ Rl ] --- [ Cl ] -+--> V(fb)
*
*   Egain      an ideal VCVS: e = -A * V(fb) / (1 + s/wp)
*   Rs         the driver's output resistance   (RS)
*   Rl, Cl     the load network, whose response IS the feedback quantity fb
*
* Around the loop, with the break shorted:
*
*   T(s) = A/(1+s/wp) * Zl(s)/(Rs + Zl(s)),  Zl(s) = Rl + 1/(sCl)
*
* i.e. exactly the "G * Zl/(Zs+Zl)" form the dual-injection formula is
* supposed to recover. Naive voltage injection instead returns
* Tv = A/(1+s/wp) + Rs/Zl, which blows up as Zl falls -- here Zl -> Rl = 10
* ohm while Rs = 1e5 ohm, so Tv is wrong by ~80 dB in the decade that
* decides the margins.
*
* selftest.py substitutes nothing: this deck is self-contained and prints
* three columns per frequency (dual-injection T, naive Tv, analytic T) which
* selftest.py compares.
*
* ---------------------------------------------------------------------------
* Second reference loop: a deliberately RESURGING loop gain (issue #59)
* ---------------------------------------------------------------------------
* The loop above is monotonic through crossover, so it can only ever show
* that the resurgence metric does not fire when it should not. The second
* loop below is the positive control: the same topology with the load
* network's capacitor put in series with an inductor, giving a lightly damped
* resonance ABOVE the first 0 dB crossing.
*
*   T2(s) = A2/(1+s/wp) * (1/sCL2)/(RS + RL + sLL2 + 1/sCL2)
*
* which is 40 dB at DC, crosses 0 dB falling at ~108 kHz, dips to about
* -3.7 dB and then climbs back to about +14 dB at the ~398 kHz resonance
* before falling for good -- exactly the shape DR-0008 found on the real loop,
* built here from ideal elements so the answer is known in closed form. The
* resonance is placed on a `dec 50` grid point so the sampled peak and the
* continuous peak agree to ~0.02 dB.
*
* ---------------------------------------------------------------------------
* Third reference loop: a HIGH-Q resonance the `dec 50` grid MISSES entirely
* (issue #58)
* ---------------------------------------------------------------------------
* Loop 2 above deliberately sits ON a `dec 50` grid point, so it proves the
* resurgence metric is *accurate when sampled*. It says nothing about whether
* `dec 50` samples a sharp feature at all. Loop 3 is that missing case: same
* topology, a much higher Q (80 vs 20) resonance placed at a frequency chosen
* to be near-worst-case for the OLD `dec 50` grid and EXACTLY worst-case for
* the NEW one, so the same loop tests both halves of the policy honestly:
*
*   f_res3 = 10^(2244.5/400) Hz = 408554.5 Hz
*
* Counting the log grid up from 1 Hz, that exponent sits exactly halfway
* between the `dec 400` grid points 10^(2244/400) and 10^(2245/400) -- the
* worst sampling offset a `dec 400` sweep has -- and 0.00875 decades from the
* nearest `dec 50` point (0.01 being that grid's worst possible offset), i.e.
* 87.5 % of worst case there. Placing it at the dec-50 midpoint instead would
* have made it land exactly ON a dec-400 grid point, which would have flattered
* the new policy by testing it at its BEST case; this placement does the
* opposite.
*
* `A3` is chosen so the true continuous peak clears 0 dB by only a few dB,
* narrow enough that every neighbouring `dec 50` sample reads well below 0 dB.
* A `dec 50` sweep therefore reports this loop as cleanly non-resurging (a
* false PASS on the DR-0008 precondition check) despite a real, analytically
* known resurgence above the first crossing -- issue #58's general concern (a
* coarse grid can misreport *any* sharp feature, not only the specific RHP
* mechanism #59 already detects) made concrete and falsifiable. selftest.py
* checks both halves: that the OLD default (`dec 50`) reads a false negative
* on this loop, and that the NEW default `sweep.py` now runs (`dec 400`, a
* single global bump -- see sweep.py's `AC_DEC` comment) recovers the true
* peak at its own worst-case sampling offset, within the analytic bound
* sweep.py's comment derives.

.param A=1000
.param RP=1k
.param CP=159.1549430918954n
.param RS=1e5
.param RL=10
.param CL=1e-9
* wp = 1/(RP*CP) = 6283.185307 rad/s  (fp = 1 kHz)
* second (resurging) loop; same pole, same source/load resistances
.param A2=100
.param LL2=0.8
.param CL2=0.2e-12
* f_res = 1/(2*pi*sqrt(LL2*CL2)) = 397887 Hz, Q = sqrt(LL2/CL2)/(RS+RL) = 20.0
* third (high-Q, grid-blind-spot) loop; same pole, same source/load
* resistances, much higher Q, resonance at the worst-case dec-400 offset
* (and 87.5% of worst case for dec 50) -- see the header comment.
.param A3=8
.param LL3=3.1167613229529993
.param CL3=48.68965725279348e-15
* f_res = 10^(2244.5/400) = 408554.5015 Hz, i.e. the geometric midpoint of the
* dec-400 grid points 10^(2244/400) and 10^(2245/400) Hz counted from 1 Hz.
* Q = sqrt(LL3/CL3)/(RS+RL) = 80.0; LL3 = Q*(RS+RL)/(2*pi*f_res) and
* CL3 = 1/(2*pi*f_res*Q*(RS+RL)). A3 = 8 puts the resonant peak at
* |T3| ~ A3*Q/(f_res/fp) = +3.9 dB, which is the smallest resurgence that is
* still unambiguously above the DR-0008 bar -- deliberately small, because a
* huge one would be caught by any grid.
* See sim/loop-stability/README.md "Sweep resolution" for the bound these
* numbers are chosen to exercise.

* --- the loop ------------------------------------------------------------
* single-pole inverting gain block, built from primitives (no LAPLACE):
*   Egain gives -A*V(fb); RP/CP make the pole; Ebuf isolates it so the
*   driver's output resistance at the break is exactly RS.
Egain G1 0 FB 0 {-1*A}
Rp G1 P {RP}
Cp P 0 {CP}
Ebuf EOUT 0 P 0 1
Rs EOUT AINJ {RS}

* injection network (identical topology to tb_loop_stability.spice.in)
Vinj AINJ BINJ DC 0 AC 0
Iinj 0 BINJ DC 0 AC 0

* load network; its node voltage is the feedback quantity
Rl BINJ FB {RL}
Cl FB 0 {CL}

* --- second loop: identical topology, resonant load network --------------
* Independent of the loop above (they share only ground), and its injection
* sources are AC 0 while the first loop is being measured, so neither loop
* perturbs the other's answer.
Egain2 G2 0 FB2 0 {-1*A2}
Rp2 G2 P2 {RP}
Cp2 P2 0 {CP}
Ebuf2 EOUT2 0 P2 0 1
Rs2 EOUT2 AINJ2 {RS}
Vinj2 AINJ2 BINJ2 DC 0 AC 0
Iinj2 0 BINJ2 DC 0 AC 0
Rl2 BINJ2 NL2 {RL}
Ll2 NL2 FB2 {LL2}
Cl2 FB2 0 {CL2}

* --- third loop: identical topology, high-Q worst-case-aligned resonance --
* Independent of the two loops above (they share only ground).
Egain3 G3 0 FB3 0 {-1*A3}
Rp3 G3 P3 {RP}
Cp3 P3 0 {CP}
Ebuf3 EOUT3 0 P3 0 1
Rs3 EOUT3 AINJ3 {RS}
Vinj3 AINJ3 BINJ3 DC 0 AC 0
Iinj3 0 BINJ3 DC 0 AC 0
Rl3 BINJ3 NL3 {RL}
Ll3 NL3 FB3 {LL3}
Cl3 FB3 0 {CL3}

.control
set noaskquit

* ---- voltage injection ---------------------------------------------------
alter @Vinj[acmag] = 1
alter @Iinj[acmag] = 0
ac dec 20 1 1e9
let tv = -v(ainj)/v(binj)
set vplot = $curplot

* ---- current injection ---------------------------------------------------
alter @Vinj[acmag] = 0
alter @Iinj[acmag] = 1
ac dec 20 1 1e9
let ti = -i(vinj)/(i(vinj)+1)
let tvv = {$vplot}.tv

* ---- dual-injection (Tian) loop gain ------------------------------------
let t = (tvv*ti - 1)/(tvv + ti + 2)

* ---- analytic reference --------------------------------------------------
* Around the loop: the driver's open-circuit return gain from V(BINJ) is
*   G = -A/(1+s/wp) * [ (1/sCL) / (RL + 1/sCL) ]      (the RL/CL divider)
* and the break sees Zs = RS, Zl = RL + 1/sCL, so
*   T = |G| * Zl/(Zs+Zl) = A/(1+s/wp) * (1/sCL)/(RS + RL + 1/sCL)
* which is what the dual-injection formula must reproduce exactly.
* .param values are not visible as control-language vectors, so the same
* numbers are restated here; selftest.py asserts the two stay in step by
* parsing both the netlist and this block.
let a0 = 1000
let wp0 = 1/(1e3*159.1549430918954e-9)
let rs0 = 1e5
let rl0 = 10
let cl0 = 1e-9
let jw = 2*pi*frequency*i
let zc = 1/(jw*cl0)
let tref = (a0/(1+jw/wp0)) * zc/(rs0+rl0+zc)

let e_db = db(t) - db(tref)
let e_ph = 180*(cph(t)-cph(tref))/pi
let naive_db = db(tvv) - db(tref)

* ---- margin extraction, byte-for-byte the idiom the real deck uses -------
let tdb = db(t)
let tph = 180*cph(t)/pi
meas ac f0 when tdb=0 fall=1
meas ac phx find tph when tdb=0 fall=1

* ---- resurgence, byte-for-byte the idiom the real deck uses --------------
* Negative control: this loop's |T| falls monotonically through crossover, so
* every point above the crossing is below unity and the metric MUST come out
* negative. The scan starts a FIXED 5% above f0 (issue #69), independent of
* the grid this loop happens to be swept at (dec 20).
let fres = f0*1.05
meas ac tres max tdb from=$&fres to=1e9
echo "MARGINS f0_hz=$&f0 phase_at_f0_deg=$&phx resurgence_db=$&tres"

echo "* columns: freq_hz t_db t_ph_deg tref_db tref_ph_deg err_db err_ph_deg naive_err_db"
print frequency db(t) 180*cph(t)/pi db(tref) 180*cph(tref)/pi e_db e_ph naive_db

* ---- invariance check: SAME loop 1, a SECOND AC_DEC (issue #69) ----------
* resurgence_db is meant to report sup|T| over (f0, F_STOP] -- a quantity
* that does not depend on the sweep's frequency resolution. Now that the
* scan starts a FIXED fraction of f0 rather than one AC-grid step above it,
* re-measuring the SAME netlist at a different AC_DEC must agree to a small,
* grid-quantization-only tolerance -- exactly the property the old
* `f0*10^(1/AC_DEC)` idiom lacked (issue #69's measured evidence: raising
* the real deck's AC_DEC from 50 to 400 alone moved resurgence_db at all
* 4536 matrix points by +0.061...+2.362 dB, with phase margin and crossover
* essentially unmoved). Re-measure loop 1 at dec 400 -- the real deck's
* current default -- and selftest.py compares it against the dec 20 value
* already measured above.
alter @Vinj[acmag] = 1
alter @Iinj[acmag] = 0
ac dec 400 1 1e9
let tvI = -v(ainj)/v(binj)
set vplotI = $curplot

alter @Vinj[acmag] = 0
alter @Iinj[acmag] = 1
ac dec 400 1 1e9
let tiI = -i(vinj)/(i(vinj)+1)
let tvvI = {$vplotI}.tvI

let tI = (tvvI*tiI - 1)/(tvvI + tiI + 2)
let tdbI = db(tI)
meas ac f0I when tdbI=0 fall=1
let fresI = f0I*1.05
meas ac tresI max tdbI from=$&fresI to=1e9
echo "INVARIANCE ac_dec=400 f0_hz=$&f0I resurgence_db=$&tresI"

* ---- second reference loop: the resurgence POSITIVE control -------------
* Same extraction, same idiom, on a loop whose gain deliberately climbs back
* above 0 dB after its first crossing. Run at dec 50 -- the real deck's AC
* resolution -- so the metric is exercised on the grid it actually runs on.
alter @Vinj[acmag] = 0
alter @Iinj[acmag] = 0
alter @Vinj2[acmag] = 1
alter @Iinj2[acmag] = 0
ac dec 50 1 1e9
let tv2 = -v(ainj2)/v(binj2)
set vplot2 = $curplot

alter @Vinj2[acmag] = 0
alter @Iinj2[acmag] = 1
ac dec 50 1 1e9
let ti2 = -i(vinj2)/(i(vinj2)+1)
let tvv2 = {$vplot2}.tv2

let t2 = (tvv2*ti2 - 1)/(tvv2 + ti2 + 2)
let tdb2 = db(t2)
meas ac f02 when tdb2=0 fall=1
let fres2 = f02*1.05
meas ac tres2 max tdb2 from=$&fres2 to=1e9
echo "RESURGING ac_dec=50 f0_hz=$&f02 resurgence_db=$&tres2"

* ---- third reference loop: the grid BLIND SPOT (issue #58) ---------------
* First at `dec 50` -- the OLD default, and byte-for-byte the real deck's
* previous idiom -- to reproduce the false-negative issue #58 describes: a
* real resurgence the coarse grid samples as a clean pass.
alter @Vinj2[acmag] = 0
alter @Iinj2[acmag] = 0
alter @Vinj3[acmag] = 1
alter @Iinj3[acmag] = 0
ac dec 50 1 1e9
let tv3 = -v(ainj3)/v(binj3)
set vplot3 = $curplot

alter @Vinj3[acmag] = 0
alter @Iinj3[acmag] = 1
ac dec 50 1 1e9
let ti3 = -i(vinj3)/(i(vinj3)+1)
let tvv3 = {$vplot3}.tv3

let t3 = (tvv3*ti3 - 1)/(tvv3 + ti3 + 2)
let tdb3 = db(t3)
let tph3 = 180*cph(t3)/pi
meas ac f03 when tdb3=0 fall=1
let fres3 = f03*1.05
meas ac tres3_coarse max tdb3 from=$&fres3 to=1e9
* The terminal UNWRAPPED phase, far above the resonance, is the direct test
* of whether cph() picked the right 360 deg branch on the way through it --
* the question issue #58 raises about the real deck's `tph`. This loop is a
* 3-pole minimum-phase response (one real pole plus the resonant pair), so
* the analytic answer is -270 deg regardless of AC resolution; anything
* 360 deg away from that is a mis-unwrap.
meas ac ph3hi_coarse find tph3 at=1e8
echo "GRIDBLIND coarse ac_dec=50 f0_hz=$&f03 resurgence_coarse_db=$&tres3_coarse phase_1e8_deg=$&ph3hi_coarse"

* ---- same loop, at the NEW default AC_DEC (issue #58) --------------------
* sweep.py's resolution policy is a single global bump to `dec 400`, not a
* two-pass local refine -- see sweep.py's `AC_DEC` comment and
* sim/loop-stability/README.md "Sweep resolution" for why. Same idiom, same
* reference loop, just denser.
alter @Vinj3[acmag] = 1
alter @Iinj3[acmag] = 0
ac dec 400 1 1e9
let tv3n = -v(ainj3)/v(binj3)
set vplot3n = $curplot

alter @Vinj3[acmag] = 0
alter @Iinj3[acmag] = 1
ac dec 400 1 1e9
let ti3n = -i(vinj3)/(i(vinj3)+1)
let tvv3n = {$vplot3n}.tv3n

let t3n = (tvv3n*ti3n - 1)/(tvv3n + ti3n + 2)
let tdb3n = db(t3n)
let tph3n = 180*cph(t3n)/pi
meas ac f03n when tdb3n=0 fall=1
let fres3n = f03n*1.05
meas ac tres3_new max tdb3n from=$&fres3n to=1e9
meas ac ph3hi_new find tph3n at=1e8
echo "GRIDBLIND new ac_dec=400 f0_hz=$&f03n resurgence_new_db=$&tres3_new phase_1e8_deg=$&ph3hi_new"

echo "* SELFTEST COMPLETE"
.endc
.end
