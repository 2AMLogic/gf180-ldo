* load-transient -- stimulus fragment for ldo_core (issue #12)
*
* Primary claim: load-transient step response (README.md Target
* specification, "Load transient" row; DR-0004 amendment A4): 1<->50 mA
* step, 1 us edges, C_eff = 0.33 uF (DR-0001's stability-window floor,
* the hardest corner for this row) + 0-500 mOhm ESR (100 mOhm nominal
* used here).
*
* Supplementary: after the load step settles, the same deck also exercises
* a dynamic *line* step (+/-10% around this PVT point's own Vin, via
* {vdd_val}) -- NOT a distinct ratified spec row (the ratified 'Line reg'
* row is DC-only, see sim/line-regulation/), included because the original
* issue #12 body asked for "load-transient and line-transient response" as
* one item. Flagged as supplementary throughout tb.json.
*
* Timeline (see tb.json's analyses "tran ..." + "meas tran ..." lines):
*   t=0..50us    : Iload=1mA,  Vsup={vdd_val}                (steady state)
*   t=50-51us    : Iload steps 1mA -> 50mA (1us edge)
*   t=51-150us   : Iload=50mA                                 (load-step window)
*   t=150-151us  : Iload steps 50mA -> 1mA (1us edge)
*   t=151-200us  : Iload=1mA, settle
*   t=200-201us  : Vsup steps {vdd_val} -> {vdd_val*0.9} (1us edge)
*   t=201-300us  : Vsup={vdd_val*0.9}                         (line-step window, low)
*   t=300-301us  : Vsup steps {vdd_val*0.9} -> {vdd_val*1.1} (1us edge)
*   t=301-400us  : Vsup={vdd_val*1.1}                         (line-step window, high)
*
* EN is tied to VIN at instantiation (enabled throughout).
Vsup VIN 0 PWL(0 {vdd_val} 200u {vdd_val} 201u {vdd_val*0.9} 300u {vdd_val*0.9}
+ 301u {vdd_val*1.1} 400u {vdd_val*1.1})
Xdut VIN VOUT VIN 0 LOOP LOOP ldo_core

* --- Compliance-limited load sink (#46) --------------------------------
* Vilc carries the COMMANDED load current as a number of volts (1 V == 1 A),
* so the load profile above is written as a PWL on Vilc. It is a control
* node only and conducts no circuit current. Bload draws that current out
* of VOUT through the 0 V ammeter Vlmeas, scaled by a compliance factor
* that is 1 for VOUT well above ground and 0 at or below it:
*     f(VOUT) = 0.5 * (1 + tanh((VOUT - 0.2) / 0.05))
* At VOUT >= 1.0 V, 1 - f < 1.3e-14 and df/dVOUT < 5.1e-13 per volt (so the
* sink's own small-signal conductance is under 2.6e-14 S even at 50 mA), so
* the sink is an ideal current sink to well past double precision anywhere
* above 1.0 V. Three measurements keep that from being an assumption:
*   - iload_err_max_ua takes the worst |delivered - commanded| load current
*     over EVERY timepoint of the run and checks it under 1 uA. This is the
*     direct statement of "the compliance bound never engaged" and needs no
*     assumption about how deep VOUT went.
*   - iload_plateau_ma checks the delivered current against the commanded
*     50 mA across the load-step plateau.
*   - vout_min_global_v reports the MINIMUM of v(vout) over the whole run,
*     so the excursion depth is on the record. Its 0.5 V floor comes from
*     the compliance factor itself: 1 - f = 6.2e-6 at 0.5 V (0.31 uA at
*     50 mA), the first point where the sink stops being ideal to far
*     better than the 1 uA band above. The deepest any corner actually
*     reaches is 0.984 V, where 1 - f is still 2.4e-14.
*
* What the bound removes is the *unphysical* branch of an ideal sink. An
* ideal sink demands its current at any terminal voltage, including tens of
* volts BELOW ground, where the only thing that can supply it is
* forward-biased substrate junctions inside the PDK device models. That is
* a genuine second DC solution of this deck's t=0 operating point, not a
* convergence failure, and a cold Newton-Raphson start reached it at most
* PVT points (#40, #46) -- which then poisoned the whole transient. No real
* load sinks current from a rail below its own ground, so bounding the sink
* at 0 V deletes that solution instead of hiding it. See
* sim/harness/README.md, "Compliance-limited load sinks".
Vilc ILC 0 PWL(0 1m 50u 1m 51u 50m 150u 50m 151u 1m 400u 1m)
Bload VOUT NLOAD I = 'v(ilc) * 0.5 * (1 + tanh((v(vout) - 0.2) / 0.05))'
Vlmeas NLOAD 0 DC 0

Resr VOUT n_esr 0.1
Cout n_esr 0 0.33u
