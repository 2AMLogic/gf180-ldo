* psrr-vs-freq -- stimulus fragment for ldo_core (issue #12)
*
* PSRR vs frequency (README.md Target specification, "PSRR" row; DR-0004
* amendment A7): >50dB @ 1kHz (binding -- light load, per note 1) and
* >20dB @ 100kHz, C_eff=1uF nominal. A small-signal AC source rides on Vin
* (Vsup ... AC 1); PSRR(f) = -Vout(f)/Vin(f) in dB = -vdb(vout) since the
* 1V AC stimulus is 0dB.
*
* Scoped to the ratified binding condition, Iload=1mA (light load) --
* NOT also swept at 50mA in this same deck. Combining two DC bias points
* (via ngspice's "alter" between two .ac runs) in one control block was
* tried and rejected during implementation: ngspice's per-.meas result
* vectors (and any "let" derived from them) go out of scope as soon as a
* later analysis becomes the current plot, so a second .ac after "alter"
* silently drops the first .ac's captured values instead of erroring
* (confirmed by hand: the harness's print-after-all-lets ordering emits
* the SAME value for both "1mA" and "50mA" print lines).
*
* The 50mA condition the ratified row also names is therefore run as its
* own sibling experiment rather than in this deck: sim/psrr-vs-freq-50ma/
* (#99) -- same DUT, same stimulus and output network, same full PVT
* sweep, its own record and its own separate verdict. This deck stays the
* 1mA condition only; the two verdicts are never merged.
Vsup VIN 0 DC {vdd_val} AC 1
* --- Reference (issue #174 / DR-0021) ------------------------------------
* VREF is a TOP-LEVEL PORT of ldo_core as of #174; it used to be an internal
* net driven by Vref1, an ideal 1.2 V vsource instantiated INSIDE the
* subcircuit. That source is deleted from design/ldo_core.sch and reappears
* here, unchanged, at deck level. This is an electrical no-op by
* construction: an ideal vsource is an ideal vsource wherever it is
* declared, its return was already the cell's VSS port (node 0 here), and it
* is an AC short to ground in both placements -- so DC operating points, .ac
* transfers and transients are all identical to the pre-#174 deck. The point
* of the move is that the idealization is now visible at the interface and a
* real reference (a bandgap block, or the Chipalooza Challenge #5 harness's
* bandgap-referenced bias-voltage slot) can drive it without editing the
* schematic. One source serves every DUT instance in this deck: an ideal
* source has zero output impedance, so instances cannot interact through it.
Vref VREF 0 DC 1.2

Xdut VIN VOUT VIN 0 LOOP LOOP VREF ldo_core

* --- Compliance-limited load sink (#46) --------------------------------
* Vilc carries the COMMANDED load current as a number of volts (1 V == 1 A).
* It is a control node only and conducts no circuit current. Bload draws
* that current out of VOUT through the 0 V ammeter Vlmeas, scaled by a
* compliance factor that is 1 for VOUT well above ground and 0 at or below
* it:
*     f(VOUT) = 0.5 * (1 + tanh((VOUT - 0.2) / 0.05))
* At VOUT >= 1.0 V, 1 - f < 1.3e-14, so the DC sink is ideal to well past
* double precision; and -- what matters for an AC measurement -- the
* small-signal conductance the sink presents at the operating point is
* df/dVOUT * v(ilc) < 5.1e-16 S at 1 mA (and ~6e-30 S at the ~1.8 V this
* design actually regulates to), i.e. an open circuit at AC exactly like the
* ideal sink it replaces. dc_vout_v / dc_iload_ma below read the .op plot
* directly so both properties are checked at every corner instead of
* assumed.
*
* The "op" entry in tb.json's analyses list exists for that reporting, not
* to steer the .ac: ngspice's ac command solves its own operating point.
* Verified by hand at tt_27c_3.30v (#46): with the OLD ideal sink, running
* ac cold with no preceding op gives vdb(vout)@1kHz = +25.2 dB (a
* small-signal expansion about the sub-ground root, i.e. PSRR = -25 dB);
* with this compliance-limited sink the same cold ac gives -77.91 dB
* (PSRR = +77.91 dB), identical to the op-then-ac ordering. The fix is
* therefore order-independent -- the unphysical root is gone, not merely
* avoided by a lucky initial guess.
*
* What the bound removes is the *unphysical* branch of an ideal sink. An
* ideal sink demands its current at any terminal voltage, including tens of
* volts BELOW ground, where the only thing that can supply it is
* forward-biased substrate junctions inside the PDK device models. That is
* a genuine second solution for the operating point this .ac linearizes
* around, not a convergence failure, and a cold Newton-Raphson start
* reached it at most PVT points (#40, #46) -- which makes the small-signal
* PSRR that follows meaningless. No real load sinks current from a rail
* below its own ground, so bounding the sink at 0 V deletes that solution
* instead of hiding it. See sim/harness/README.md, "Compliance-limited load
* sinks".
*
* What the bound does NOT delete (#304). It deletes the SINK-SUSTAINED
* root above -- the one the sink's own demand holds below ground. Below
* the knee the sink is exactly 0 A and 0 S (f underflows to 0.0 in double
* for VOUT <= -0.753 V), so the load network is absent from the DC
* equations there and anything the solver reports at a sub-ground VOUT
* with i(vlmeas) = 0 is beyond the sink's reach by construction -- no knee
* or softness can delete it, because the sink has no term left to remove.
* Record 20260923-084323-a6c95f8 hit exactly that at fs_125c_3.63v
* (dc_vout_v = -64.75 V, dc_iload_ma = 0) on the DUT netlist of the day;
* #304 measured it and found it is not a second solution at all but a
* false convergence on the continuation ladder's first rung, admitted by
* SPICE's RELATIVE convergence test 64 V from ground. dc_vout_v and
* dc_iload_ma below are what catch that class -- they are the mechanism,
* not a formality. See sim/harness/README.md, "What the bound cannot
* reach", for the evidence and for the reltol-ladder recipe that tells a
* false convergence from a genuine root.
Vilc ILC 0 DC 1m
Bload VOUT NLOAD I = 'v(ilc) * 0.5 * (1 + tanh((v(vout) - 0.2) / 0.05))'
Vlmeas NLOAD 0 DC 0

Resr VOUT n_esr 0.1
Cout n_esr 0 1u
